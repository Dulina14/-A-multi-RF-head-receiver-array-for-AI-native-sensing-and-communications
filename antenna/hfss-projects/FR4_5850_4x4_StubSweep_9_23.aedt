# Ansys Electronics Desktop project, version 2025.2
materials:
  FR4_Assumed_6GHz: permittivity=4.4 permeability=1 dielectric_loss_tangent=0.02
  vacuum: permittivity=1
  copper: permeability=0.999991 conductivity=58000000

design Array4x4_StubSweep_5p85 (HFSS, HFSS Hybrid Modal Network, model units mm)
variables:
  Wp = 15.594mm
  Lp = 10.3879588mm
  h = 1.6mm
  tCu = 0.035mm
  dx = 40.25491051mm
  dy = 35.86851091mm
  feedRise = 3mm
  boardX = 161mm
  boardY = 152mm
  airPad = 13mm
  junctionR = 1.5415mm
  Lq50Taper = 3mm
  L50PatchTaper = 3mm
  teeApproach = 4mm
  inputY = 0mm
  W50 = 3.083mm
  W70 = 1.6055mm
  WpT = 1mm
  LpT = 7.182423598mm
  stubD = 7.4mm
  stubL = 3.05mm
  cOver = 0.05mm
  Lq1 = 7.064162606mm
  Lq2 = 7.064162606mm
  Lq3 = 7.064162606mm
  Lq4 = 7.064162606mm
  f0 = 5.85GHz
geometry:
  Substrate [FR4_Assumed_6GHz] = box(corner=(-boardX/2, -boardY/2, 0mm), size=(boardX, boardY, h))
  Ground [copper] = box(corner=(-boardX/2, -boardY/2, -tCu), size=(boardX, boardY, tCu))
  TopCopper [copper] = cylinder(axis=Z, base_centre=(0mm, (((Lp*0.5)*-1)-feedRise), h), radius=junctionR, height=tCu)
  Input50_Rerouted = polyline(z=h+tCu/2, xy: ((boardX*0.5), inputY) ((teeApproach+(inputY-(((Lp*0.5)*-1)-feedRise))), inputY) (teeApproach, (((Lp*0.5)*-1)-feedRise)) ((0mm+(cOver*-1)), ((((Lp*0.5)*-1)-feedRise)+(cOver*0))), section rectangle width=W50 height=tCu bend_type=Curved)
  InputMatchStub = polyline(((((boardX*0.5)-stubD)+(cOver*0)), (inputY+(cOver*-1)), h+tCu/2) (((boardX*0.5)-stubD), (inputY+stubL), h+tCu/2), section rectangle width=W50 height=tCu bend_type=Curved)
  RoundTee_InputMatch = cylinder(axis=Z, base_centre=(((boardX*0.5)-stubD), inputY, h), radius=(W50*0.5), height=tCu)
  Branch_0_Q = box(corner=(((((((0mm+(dx*-1.5))+(dx*-0.5))+(dx*0.5))+(dx*1.5))*0.25)-(W70*0.5)), ((((((((0mm+(dy*-1.5))+(dy*-0.5))+(dy*0.5))+(dy*1.5))*0.25)+(((Lp*0.5)*-1)-feedRise))+(Lq1*-1))+(cOver*-1)), h), size=(W70, ((((((((0mm+(dy*-1.5))+(dy*-0.5))+(dy*0.5))+(dy*1.5))*0.25)+(((Lp*0.5)*-1)-feedRise))+(cOver*1))-((((((((0mm+(dy*-1.5))+(dy*-0.5))+(dy*0.5))+(dy*1.5))*0.25)+(((Lp*0.5)*-1)-feedRise))+(Lq1*-1))+(cOver*-1))), tCu))
  Branch_0_Q50_Taper = polyline(z=h, xy: ((((((((0mm+(dx*-1.5))+(dx*-0.5))+(dx*0.5))+(dx*1.5))*0.25)+(cOver*0))-(W70*0.5)), (((((((((0mm+(dy*-1.5))+(dy*-0.5))+(dy*0.5))+(dy*1.5))*0.25)+(((Lp*0.5)*-1)-feedRise))+(Lq1*-1))+(cOver*1))-(W70*0))) ((((((((0mm+(dx*-1.5))+(dx*-0.5))+(dx*0.5))+(dx*1.5))*0.25)+(cOver*0))-(W50*0.5)), ((((((((((0mm+(dy*-1.5))+(dy*-0.5))+(dy*0.5))+(dy*1.5))*0.25)+(((Lp*0.5)*-1)-feedRise))+(Lq1*-1))+(Lq50Taper*-1))+(cOver*-1))-(W50*0))) ((((((((0mm+(dx*-1.5))+(dx*-0.5))+(dx*0.5))+(dx*1.5))*0.25)+(cOver*0))+(W50*0.5)), ((((((((((0mm+(dy*-1.5))+(dy*-0.5))+(dy*0.5))+(dy*1.5))*0.25)+(((Lp*0.5)*-1)-feedRise))+(Lq1*-1))+(Lq50Taper*-1))+(cOver*-1))+(W50*0))) ((((((((0mm+(dx*-1.5))+(dx*-0.5))+(dx*0.5))+(dx*1.5))*0.25)+(cOver*0))+(W70*0.5)), (((((((((0mm+(dy*-1.5))+(dy*-0.5))+(dy*0.5))+(dy*1.5))*0.25)+(((Lp*0.5)*-1)-feedRise))+(Lq1*-1))+(cOver*1))+(W70*0))), closed, covered)
  Branch_0_Q50_Taper.thicken(tCu)
  Branch_0_50 = box(corner=(((((((0mm+(dx*-1.5))+(dx*-0.5))+(dx*0.5))+(dx*1.5))*0.25)-(W50*0.5)), (((((0mm+(dy*-1.5))+(dy*-0.5))*0.5)+(((Lp*0.5)*-1)-feedRise))+(cOver*-1)), h), size=(W50, ((((((((((0mm+(dy*-1.5))+(dy*-0.5))+(dy*0.5))+(dy*1.5))*0.25)+(((Lp*0.5)*-1)-feedRise))+(Lq1*-1))+(Lq50Taper*-1))+(cOver*1))-(((((0mm+(dy*-1.5))+(dy*-0.5))*0.5)+(((Lp*0.5)*-1)-feedRise))+(cOver*-1))), tCu))
  RoundTee_0 = cylinder(axis=Z, base_centre=((((((0mm+(dx*-1.5))+(dx*-0.5))+(dx*0.5))+(dx*1.5))*0.25), ((((0mm+(dy*-1.5))+(dy*-0.5))*0.5)+(((Lp*0.5)*-1)-feedRise)), h), radius=junctionR, height=tCu)
  Branch_00_Q = box(corner=((((((((0mm+(dx*-1.5))+(dx*-0.5))+(dx*0.5))+(dx*1.5))*0.25)+(Lq2*-1))+(cOver*-1)), (((((0mm+(dy*-1.5))+(dy*-0.5))*0.5)+(((Lp*0.5)*-1)-feedRise))-(W70*0.5)), h), size=((((((((0mm+(dx*-1.5))+(dx*-0.5))+(dx*0.5))+(dx*1.5))*0.25)+(cOver*1))-(((((((0mm+(dx*-1.5))+(dx*-0.5))+(dx*0.5))+(dx*1.5))*0.25)+(Lq2*-1))+(cOver*-1))), W70, tCu))
  Branch_00_Q50_Taper = polyline(z=h, xy: (((((((((0mm+(dx*-1.5))+(dx*-0.5))+(dx*0.5))+(dx*1.5))*0.25)+(Lq2*-1))+(cOver*0.7071067812))-(W70*-0.3535533906)), ((((((0mm+(dy*-1.5))+(dy*-0.5))*0.5)+(((Lp*0.5)*-1)-feedRise))+(cOver*-0.7071067812))-(W70*-0.3535533906))) ((((((((((0mm+(dx*-1.5))+(dx*-0.5))+(dx*0.5))+(dx*1.5))*0.25)+(Lq2*-1))+(Lq50Taper*-0.7071067812))+(cOver*-0.7071067812))-(W50*-0.3535533906)), (((((((0mm+(dy*-1.5))+(dy*-0.5))*0.5)+(((Lp*0.5)*-1)-feedRise))+(Lq50Taper*0.7071067812))+(cOver*0.7071067812))-(W50*-0.3535533906))) ((((((((((0mm+(dx*-1.5))+(dx*-0.5))+(dx*0.5))+(dx*1.5))*0.25)+(Lq2*-1))+(Lq50Taper*-0.7071067812))+(cOver*-0.7071067812))+(W50*-0.3535533906)), (((((((0mm+(dy*-1.5))+(dy*-0.5))*0.5)+(((Lp*0.5)*-1)-feedRise))+(Lq50Taper*0.7071067812))+(cOver*0.7071067812))+(W50*-0.3535533906))) (((((((((0mm+(dx*-1.5))+(dx*-0.5))+(dx*0.5))+(dx*1.5))*0.25)+(Lq2*-1))+(cOver*0.7071067812))+(W70*-0.3535533906)), ((((((0mm+(dy*-1.5))+(dy*-0.5))*0.5)+(((Lp*0.5)*-1)-feedRise))+(cOver*-0.7071067812))+(W70*-0.3535533906))), closed, covered)
  Branch_00_Q50_Taper.thicken(tCu)
  Branch_00_BendFill = cylinder(axis=Z, base_centre=(((((((0mm+(dx*-1.5))+(dx*-0.5))+(dx*0.5))+(dx*1.5))*0.25)+(Lq2*-1)), ((((0mm+(dy*-1.5))+(dy*-0.5))*0.5)+(((Lp*0.5)*-1)-feedRise)), h), radius=(W70*0.62), height=tCu)
  Branch_00_50_Clearance = polyline(z=h+tCu/2, xy: (((((((((0mm+(dx*-1.5))+(dx*-0.5))+(dx*0.5))+(dx*1.5))*0.25)+(Lq2*-1))+(Lq50Taper*-0.7071067812))+(cOver*0.7071067812)), ((((((0mm+(dy*-1.5))+(dy*-0.5))*0.5)+(((Lp*0.5)*-1)-feedRise))+(Lq50Taper*0.7071067812))+(cOver*-0.7071067812))) ((((((((0mm+(dx*-1.5))+(dx*-0.5))+(dx*0.5))+(dx*1.5))*0.25)+(Lq2*-1))+(((Lp*0.5)+feedRise)*-1)), (((((0mm+(dy*-1.5))+(dy*-0.5))*0.5)+(((Lp*0.5)*-1)-feedRise))+((Lp*0.5)+feedRise))) ((((((0mm+(dx*-1.5))+(dx*-0.5))*0.5)-(teeApproach*-1))-(((Lp*0.5)+feedRise)*-1)), (((((0mm+(dy*-1.5))+(dy*-0.5))*0.5)+(((Lp*0.5)*-1)-feedRise))+((Lp*0.5)+feedRise))) (((((0mm+(dx*-1.5))+(dx*-0.5))*0.5)-(teeApproach*-1)), ((((0mm+(dy*-1.5))+(dy*-0.5))*0.5)+(((Lp*0.5)*-1)-feedRise))) (((((0mm+(dx*-1.5))+(dx*-0.5))*0.5)+(cOver*-1)), (((((0mm+(dy*-1.5))+(dy*-0.5))*0.5)+(((Lp*0.5)*-1)-feedRise))+(cOver*0))), section rectangle width=W50 height=tCu bend_type=Curved)
  RoundTee_00 = cylinder(axis=Z, base_centre=((((0mm+(dx*-1.5))+(dx*-0.5))*0.5), ((((0mm+(dy*-1.5))+(dy*-0.5))*0.5)+(((Lp*0.5)*-1)-feedRise)), h), radius=junctionR, height=tCu)
  Branch_000_Q = box(corner=(((((0mm+(dx*-1.5))+(dx*-0.5))*0.5)-(W70*0.5)), ((((((0mm+(dy*-1.5))+(dy*-0.5))*0.5)+(((Lp*0.5)*-1)-feedRise))+(Lq3*-1))+(cOver*-1)), h), size=(W70, ((((((0mm+(dy*-1.5))+(dy*-0.5))*0.5)+(((Lp*0.5)*-1)-feedRise))+(cOver*1))-((((((0mm+(dy*-1.5))+(dy*-0.5))*0.5)+(((Lp*0.5)*-1)-feedRise))+(Lq3*-1))+(cOver*-1))), tCu))
  Branch_000_Q50_Taper = polyline(z=h, xy: ((((((0mm+(dx*-1.5))+(dx*-0.5))*0.5)+(cOver*0))-(W70*0.5)), (((((((0mm+(dy*-1.5))+(dy*-0.5))*0.5)+(((Lp*0.5)*-1)-feedRise))+(Lq3*-1))+(cOver*1))-(W70*0))) ((((((0mm+(dx*-1.5))+(dx*-0.5))*0.5)+(cOver*0))-(W50*0.5)), ((((((((0mm+(dy*-1.5))+(dy*-0.5))*0.5)+(((Lp*0.5)*-1)-feedRise))+(Lq3*-1))+(Lq50Taper*-1))+(cOver*-1))-(W50*0))) ((((((0mm+(dx*-1.5))+(dx*-0.5))*0.5)+(cOver*0))+(W50*0.5)), ((((((((0mm+(dy*-1.5))+(dy*-0.5))*0.5)+(((Lp*0.5)*-1)-feedRise))+(Lq3*-1))+(Lq50Taper*-1))+(cOver*-1))+(W50*0))) ((((((0mm+(dx*-1.5))+(dx*-0.5))*0.5)+(cOver*0))+(W70*0.5)), (((((((0mm+(dy*-1.5))+(dy*-0.5))*0.5)+(((Lp*0.5)*-1)-feedRise))+(Lq3*-1))+(cOver*1))+(W70*0))), closed, covered)
  Branch_000_Q50_Taper.thicken(tCu)
  Branch_000_50 = box(corner=(((((0mm+(dx*-1.5))+(dx*-0.5))*0.5)-(W50*0.5)), ((((0mm+(dy*-1.5))*1)+(((Lp*0.5)*-1)-feedRise))+(cOver*-1)), h), size=(W50, ((((((((0mm+(dy*-1.5))+(dy*-0.5))*0.5)+(((Lp*0.5)*-1)-feedRise))+(Lq3*-1))+(Lq50Taper*-1))+(cOver*1))-((((0mm+(dy*-1.5))*1)+(((Lp*0.5)*-1)-feedRise))+(cOver*-1))), tCu))
  RoundTee_000 = cylinder(axis=Z, base_centre=((((0mm+(dx*-1.5))+(dx*-0.5))*0.5), (((0mm+(dy*-1.5))*1)+(((Lp*0.5)*-1)-feedRise)), h), radius=junctionR, height=tCu)
  Patch_r1_c1 = box(corner=(((dx*-1.5)-(Wp*0.5)), ((dy*-1.5)-(Lp*0.5)), h), size=(Wp, Lp, tCu))
  Branch_0000_Q = box(corner=((((((0mm+(dx*-1.5))+(dx*-0.5))*0.5)+(Lq4*-1))+(cOver*-1)), ((((0mm+(dy*-1.5))*1)+(((Lp*0.5)*-1)-feedRise))-(W70*0.5)), h), size=((((((0mm+(dx*-1.5))+(dx*-0.5))*0.5)+(cOver*1))-(((((0mm+(dx*-1.5))+(dx*-0.5))*0.5)+(Lq4*-1))+(cOver*-1))), W70, tCu))
  Branch_0000_Q50_Taper = polyline(z=h, xy: (((((((0mm+(dx*-1.5))+(dx*-0.5))*0.5)+(Lq4*-1))+(cOver*1))-(W70*0)), (((((0mm+(dy*-1.5))*1)+(((Lp*0.5)*-1)-feedRise))+(cOver*0))-(W70*-0.5))) ((((((((0mm+(dx*-1.5))+(dx*-0.5))*0.5)+(Lq4*-1))+(Lq50Taper*-1))+(cOver*-1))-(W50*0)), (((((0mm+(dy*-1.5))*1)+(((Lp*0.5)*-1)-feedRise))+(cOver*0))-(W50*-0.5))) ((((((((0mm+(dx*-1.5))+(dx*-0.5))*0.5)+(Lq4*-1))+(Lq50Taper*-1))+(cOver*-1))+(W50*0)), (((((0mm+(dy*-1.5))*1)+(((Lp*0.5)*-1)-feedRise))+(cOver*0))+(W50*-0.5))) (((((((0mm+(dx*-1.5))+(dx*-0.5))*0.5)+(Lq4*-1))+(cOver*1))+(W70*0)), (((((0mm+(dy*-1.5))*1)+(((Lp*0.5)*-1)-feedRise))+(cOver*0))+(W70*-0.5))), closed, covered)
  Branch_0000_Q50_Taper.thicken(tCu)
  Branch_0000_50 = box(corner=((((((0mm+(dx*-1.5))*1)-((LpT-feedRise)*-1))-(L50PatchTaper*-1))+(cOver*-1)), ((((0mm+(dy*-1.5))*1)+(((Lp*0.5)*-1)-feedRise))-(W50*0.5)), h), size=((((((((0mm+(dx*-1.5))+(dx*-0.5))*0.5)+(Lq4*-1))+(Lq50Taper*-1))+(cOver*1))-(((((0mm+(dx*-1.5))*1)-((LpT-feedRise)*-1))-(L50PatchTaper*-1))+(cOver*-1))), W50, tCu))
  Branch_0000_50PT_Taper = polyline(z=h, xy: (((((((0mm+(dx*-1.5))*1)-((LpT-feedRise)*-1))-(L50PatchTaper*-1))+(cOver*1))-(W50*0)), (((((0mm+(dy*-1.5))*1)+(((Lp*0.5)*-1)-feedRise))+(cOver*0))-(W50*-0.5))) ((((((0mm+(dx*-1.5))*1)-((LpT-feedRise)*-1))+(cOver*-1))-(WpT*0)), (((((0mm+(dy*-1.5))*1)+(((Lp*0.5)*-1)-feedRise))+(cOver*0))-(WpT*-0.5))) ((((((0mm+(dx*-1.5))*1)-((LpT-feedRise)*-1))+(cOver*-1))+(WpT*0)), (((((0mm+(dy*-1.5))*1)+(((Lp*0.5)*-1)-feedRise))+(cOver*0))+(WpT*-0.5))) (((((((0mm+(dx*-1.5))*1)-((LpT-feedRise)*-1))-(L50PatchTaper*-1))+(cOver*1))+(W50*0)), (((((0mm+(dy*-1.5))*1)+(((Lp*0.5)*-1)-feedRise))+(cOver*0))+(W50*-0.5))), closed, covered)
  Branch_0000_50PT_Taper.thicken(tCu)
  Branch_0000_PT = polyline(z=h+tCu/2, xy: (((((0mm+(dx*-1.5))*1)-((LpT-feedRise)*-1))+(cOver*1)), ((((0mm+(dy*-1.5))*1)+(((Lp*0.5)*-1)-feedRise))+(cOver*0))) (((0mm+(dx*-1.5))*1), (((0mm+(dy*-1.5))*1)+(((Lp*0.5)*-1)-feedRise))) ((((0mm+(dx*-1.5))*1)+(cOver*0)), (((dy*-1.5)-(Lp*0.5))+(cOver*1))), section rectangle width=WpT height=tCu bend_type=Curved)
  Patch_r1_c2 = box(corner=(((dx*-0.5)-(Wp*0.5)), ((dy*-1.5)-(Lp*0.5)), h), size=(Wp, Lp, tCu))
  Branch_0001_Q = box(corner=(((((0mm+(dx*-1.5))+(dx*-0.5))*0.5)+(cOver*-1)), ((((0mm+(dy*-1.5))*1)+(((Lp*0.5)*-1)-feedRise))-(W70*0.5)), h), size=(((((((0mm+(dx*-1.5))+(dx*-0.5))*0.5)+(Lq4*1))+(cOver*1))-((((0mm+(dx*-1.5))+(dx*-0.5))*0.5)+(cOver*-1))), W70, tCu))
  Branch_0001_Q50_Taper = polyline(z=h, xy: (((((((0mm+(dx*-1.5))+(dx*-0.5))*0.5)+(Lq4*1))+(cOver*-1))-(W70*0)), (((((0mm+(dy*-1.5))*1)+(((Lp*0.5)*-1)-feedRise))+(cOver*0))-(W70*0.5))) ((((((((0mm+(dx*-1.5))+(dx*-0.5))*0.5)+(Lq4*1))+(Lq50Taper*1))+(cOver*1))-(W50*0)), (((((0mm+(dy*-1.5))*1)+(((Lp*0.5)*-1)-feedRise))+(cOver*0))-(W50*0.5))) ((((((((0mm+(dx*-1.5))+(dx*-0.5))*0.5)+(Lq4*1))+(Lq50Taper*1))+(cOver*1))+(W50*0)), (((((0mm+(dy*-1.5))*1)+(((Lp*0.5)*-1)-feedRise))+(cOver*0))+(W50*0.5))) (((((((0mm+(dx*-1.5))+(dx*-0.5))*0.5)+(Lq4*1))+(cOver*-1))+(W70*0)), (((((0mm+(dy*-1.5))*1)+(((Lp*0.5)*-1)-feedRise))+(cOver*0))+(W70*0.5))), closed, covered)
  Branch_0001_Q50_Taper.thicken(tCu)
  Branch_0001_50 = box(corner=(((((((0mm+(dx*-1.5))+(dx*-0.5))*0.5)+(Lq4*1))+(Lq50Taper*1))+(cOver*-1)), ((((0mm+(dy*-1.5))*1)+(((Lp*0.5)*-1)-feedRise))-(W50*0.5)), h), size=(((((((0mm+(dx*-0.5))*1)-((LpT-feedRise)*1))-(L50PatchTaper*1))+(cOver*1))-((((((0mm+(dx*-1.5))+(dx*-0.5))*0.5)+(Lq4*1))+(Lq50Taper*1))+(cOver*-1))), W50, tCu))
  Branch_0001_50PT_Taper = polyline(z=h, xy: (((((((0mm+(dx*-0.5))*1)-((LpT-feedRise)*1))-(L50PatchTaper*1))+(cOver*-1))-(W50*0)), (((((0mm+(dy*-1.5))*1)+(((Lp*0.5)*-1)-feedRise))+(cOver*0))-(W50*0.5))) ((((((0mm+(dx*-0.5))*1)-((LpT-feedRise)*1))+(cOver*1))-(WpT*0)), (((((0mm+(dy*-1.5))*1)+(((Lp*0.5)*-1)-feedRise))+(cOver*0))-(WpT*0.5))) ((((((0mm+(dx*-0.5))*1)-((LpT-feedRise)*1))+(cOver*1))+(WpT*0)), (((((0mm+(dy*-1.5))*1)+(((Lp*0.5)*-1)-feedRise))+(cOver*0))+(WpT*0.5))) (((((((0mm+(dx*-0.5))*1)-((LpT-feedRise)*1))-(L50PatchTaper*1))+(cOver*-1))+(W50*0)), (((((0mm+(dy*-1.5))*1)+(((Lp*0.5)*-1)-feedRise))+(cOver*0))+(W50*0.5))), closed, covered)
  Branch_0001_50PT_Taper.thicken(tCu)
  Branch_0001_PT = polyline(z=h+tCu/2, xy: (((((0mm+(dx*-0.5))*1)-((LpT-feedRise)*1))+(cOver*-1)), ((((0mm+(dy*-1.5))*1)+(((Lp*0.5)*-1)-feedRise))+(cOver*0))) (((0mm+(dx*-0.5))*1), (((0mm+(dy*-1.5))*1)+(((Lp*0.5)*-1)-feedRise))) ((((0mm+(dx*-0.5))*1)+(cOver*0)), (((dy*-1.5)-(Lp*0.5))+(cOver*1))), section rectangle width=WpT height=tCu bend_type=Curved)
  Branch_001_Q = box(corner=(((((0mm+(dx*-1.5))+(dx*-0.5))*0.5)-(W70*0.5)), (((((0mm+(dy*-1.5))+(dy*-0.5))*0.5)+(((Lp*0.5)*-1)-feedRise))+(cOver*-1)), h), size=(W70, (((((((0mm+(dy*-1.5))+(dy*-0.5))*0.5)+(((Lp*0.5)*-1)-feedRise))+(Lq3*1))+(cOver*1))-(((((0mm+(dy*-1.5))+(dy*-0.5))*0.5)+(((Lp*0.5)*-1)-feedRise))+(cOver*-1))), tCu))
  Branch_001_Q50_Taper = polyline(z=h, xy: ((((((0mm+(dx*-1.5))+(dx*-0.5))*0.5)+(cOver*0))-(W70*-0.5)), (((((((0mm+(dy*-1.5))+(dy*-0.5))*0.5)+(((Lp*0.5)*-1)-feedRise))+(Lq3*1))+(cOver*-1))-(W70*0))) ((((((0mm+(dx*-1.5))+(dx*-0.5))*0.5)+(cOver*0))-(W50*-0.5)), ((((((((0mm+(dy*-1.5))+(dy*-0.5))*0.5)+(((Lp*0.5)*-1)-feedRise))+(Lq3*1))+(Lq50Taper*1))+(cOver*1))-(W50*0))) ((((((0mm+(dx*-1.5))+(dx*-0.5))*0.5)+(cOver*0))+(W50*-0.5)), ((((((((0mm+(dy*-1.5))+(dy*-0.5))*0.5)+(((Lp*0.5)*-1)-feedRise))+(Lq3*1))+(Lq50Taper*1))+(cOver*1))+(W50*0))) ((((((0mm+(dx*-1.5))+(dx*-0.5))*0.5)+(cOver*0))+(W70*-0.5)), (((((((0mm+(dy*-1.5))+(dy*-0.5))*0.5)+(((Lp*0.5)*-1)-feedRise))+(Lq3*1))+(cOver*-1))+(W70*0))), closed, covered)
  Branch_001_Q50_Taper.thicken(tCu)
  Branch_001_50 = box(corner=(((((0mm+(dx*-1.5))+(dx*-0.5))*0.5)-(W50*0.5)), (((((((0mm+(dy*-1.5))+(dy*-0.5))*0.5)+(((Lp*0.5)*-1)-feedRise))+(Lq3*1))+(Lq50Taper*1))+(cOver*-1)), h), size=(W50, (((((0mm+(dy*-0.5))*1)+(((Lp*0.5)*-1)-feedRise))+(cOver*1))-(((((((0mm+(dy*-1.5))+(dy*-0.5))*0.5)+(((Lp*0.5)*-1)-feedRise))+(Lq3*1))+(Lq50Taper*1))+(cOver*-1))), tCu))
  RoundTee_001 = cylinder(axis=Z, base_centre=((((0mm+(dx*-1.5))+(dx*-0.5))*0.5), (((0mm+(dy*-0.5))*1)+(((Lp*0.5)*-1)-feedRise)), h), radius=junctionR, height=tCu)
  Patch_r2_c1 = box(corner=(((dx*-1.5)-(Wp*0.5)), ((dy*-0.5)-(Lp*0.5)), h), size=(Wp, Lp, tCu))
  Branch_0010_Q = box(corner=((((((0mm+(dx*-1.5))+(dx*-0.5))*0.5)+(Lq4*-1))+(cOver*-1)), ((((0mm+(dy*-0.5))*1)+(((Lp*0.5)*-1)-feedRise))-(W70*0.5)), h), size=((((((0mm+(dx*-1.5))+(dx*-0.5))*0.5)+(cOver*1))-(((((0mm+(dx*-1.5))+(dx*-0.5))*0.5)+(Lq4*-1))+(cOver*-1))), W70, tCu))
  Branch_0010_Q50_Taper = polyline(z=h, xy: (((((((0mm+(dx*-1.5))+(dx*-0.5))*0.5)+(Lq4*-1))+(cOver*1))-(W70*0)), (((((0mm+(dy*-0.5))*1)+(((Lp*0.5)*-1)-feedRise))+(cOver*0))-(W70*-0.5))) ((((((((0mm+(dx*-1.5))+(dx*-0.5))*0.5)+(Lq4*-1))+(Lq50Taper*-1))+(cOver*-1))-(W50*0)), (((((0mm+(dy*-0.5))*1)+(((Lp*0.5)*-1)-feedRise))+(cOver*0))-(W50*-0.5))) ((((((((0mm+(dx*-1.5))+(dx*-0.5))*0.5)+(Lq4*-1))+(Lq50Taper*-1))+(cOver*-1))+(W50*0)), (((((0mm+(dy*-0.5))*1)+(((Lp*0.5)*-1)-feedRise))+(cOver*0))+(W50*-0.5))) (((((((0mm+(dx*-1.5))+(dx*-0.5))*0.5)+(Lq4*-1))+(cOver*1))+(W70*0)), (((((0mm+(dy*-0.5))*1)+(((Lp*0.5)*-1)-feedRise))+(cOver*0))+(W70*-0.5))), closed, covered)
  Branch_0010_Q50_Taper.thicken(tCu)
  Branch_0010_50 = box(corner=((((((0mm+(dx*-1.5))*1)-((LpT-feedRise)*-1))-(L50PatchTaper*-1))+(cOver*-1)), ((((0mm+(dy*-0.5))*1)+(((Lp*0.5)*-1)-feedRise))-(W50*0.5)), h), size=((((((((0mm+(dx*-1.5))+(dx*-0.5))*0.5)+(Lq4*-1))+(Lq50Taper*-1))+(cOver*1))-(((((0mm+(dx*-1.5))*1)-((LpT-feedRise)*-1))-(L50PatchTaper*-1))+(cOver*-1))), W50, tCu))
  Branch_0010_50PT_Taper = polyline(z=h, xy: (((((((0mm+(dx*-1.5))*1)-((LpT-feedRise)*-1))-(L50PatchTaper*-1))+(cOver*1))-(W50*0)), (((((0mm+(dy*-0.5))*1)+(((Lp*0.5)*-1)-feedRise))+(cOver*0))-(W50*-0.5))) ((((((0mm+(dx*-1.5))*1)-((LpT-feedRise)*-1))+(cOver*-1))-(WpT*0)), (((((0mm+(dy*-0.5))*1)+(((Lp*0.5)*-1)-feedRise))+(cOver*0))-(WpT*-0.5))) ((((((0mm+(dx*-1.5))*1)-((LpT-feedRise)*-1))+(cOver*-1))+(WpT*0)), (((((0mm+(dy*-0.5))*1)+(((Lp*0.5)*-1)-feedRise))+(cOver*0))+(WpT*-0.5))) (((((((0mm+(dx*-1.5))*1)-((LpT-feedRise)*-1))-(L50PatchTaper*-1))+(cOver*1))+(W50*0)), (((((0mm+(dy*-0.5))*1)+(((Lp*0.5)*-1)-feedRise))+(cOver*0))+(W50*-0.5))), closed, covered)
  Branch_0010_50PT_Taper.thicken(tCu)
  Branch_0010_PT = polyline(z=h+tCu/2, xy: (((((0mm+(dx*-1.5))*1)-((LpT-feedRise)*-1))+(cOver*1)), ((((0mm+(dy*-0.5))*1)+(((Lp*0.5)*-1)-feedRise))+(cOver*0))) (((0mm+(dx*-1.5))*1), (((0mm+(dy*-0.5))*1)+(((Lp*0.5)*-1)-feedRise))) ((((0mm+(dx*-1.5))*1)+(cOver*0)), (((dy*-0.5)-(Lp*0.5))+(cOver*1))), section rectangle width=WpT height=tCu bend_type=Curved)
  Patch_r2_c2 = box(corner=(((dx*-0.5)-(Wp*0.5)), ((dy*-0.5)-(Lp*0.5)), h), size=(Wp, Lp, tCu))
  Branch_0011_Q = box(corner=(((((0mm+(dx*-1.5))+(dx*-0.5))*0.5)+(cOver*-1)), ((((0mm+(dy*-0.5))*1)+(((Lp*0.5)*-1)-feedRise))-(W70*0.5)), h), size=(((((((0mm+(dx*-1.5))+(dx*-0.5))*0.5)+(Lq4*1))+(cOver*1))-((((0mm+(dx*-1.5))+(dx*-0.5))*0.5)+(cOver*-1))), W70, tCu))
  Branch_0011_Q50_Taper = polyline(z=h, xy: (((((((0mm+(dx*-1.5))+(dx*-0.5))*0.5)+(Lq4*1))+(cOver*-1))-(W70*0)), (((((0mm+(dy*-0.5))*1)+(((Lp*0.5)*-1)-feedRise))+(cOver*0))-(W70*0.5))) ((((((((0mm+(dx*-1.5))+(dx*-0.5))*0.5)+(Lq4*1))+(Lq50Taper*1))+(cOver*1))-(W50*0)), (((((0mm+(dy*-0.5))*1)+(((Lp*0.5)*-1)-feedRise))+(cOver*0))-(W50*0.5))) ((((((((0mm+(dx*-1.5))+(dx*-0.5))*0.5)+(Lq4*1))+(Lq50Taper*1))+(cOver*1))+(W50*0)), (((((0mm+(dy*-0.5))*1)+(((Lp*0.5)*-1)-feedRise))+(cOver*0))+(W50*0.5))) (((((((0mm+(dx*-1.5))+(dx*-0.5))*0.5)+(Lq4*1))+(cOver*-1))+(W70*0)), (((((0mm+(dy*-0.5))*1)+(((Lp*0.5)*-1)-feedRise))+(cOver*0))+(W70*0.5))), closed, covered)
  Branch_0011_Q50_Taper.thicken(tCu)
  Branch_0011_50 = box(corner=(((((((0mm+(dx*-1.5))+(dx*-0.5))*0.5)+(Lq4*1))+(Lq50Taper*1))+(cOver*-1)), ((((0mm+(dy*-0.5))*1)+(((Lp*0.5)*-1)-feedRise))-(W50*0.5)), h), size=(((((((0mm+(dx*-0.5))*1)-((LpT-feedRise)*1))-(L50PatchTaper*1))+(cOver*1))-((((((0mm+(dx*-1.5))+(dx*-0.5))*0.5)+(Lq4*1))+(Lq50Taper*1))+(cOver*-1))), W50, tCu))
  Branch_0011_50PT_Taper = polyline(z=h, xy: (((((((0mm+(dx*-0.5))*1)-((LpT-feedRise)*1))-(L50PatchTaper*1))+(cOver*-1))-(W50*0)), (((((0mm+(dy*-0.5))*1)+(((Lp*0.5)*-1)-feedRise))+(cOver*0))-(W50*0.5))) ((((((0mm+(dx*-0.5))*1)-((LpT-feedRise)*1))+(cOver*1))-(WpT*0)), (((((0mm+(dy*-0.5))*1)+(((Lp*0.5)*-1)-feedRise))+(cOver*0))-(WpT*0.5))) ((((((0mm+(dx*-0.5))*1)-((LpT-feedRise)*1))+(cOver*1))+(WpT*0)), (((((0mm+(dy*-0.5))*1)+(((Lp*0.5)*-1)-feedRise))+(cOver*0))+(WpT*0.5))) (((((((0mm+(dx*-0.5))*1)-((LpT-feedRise)*1))-(L50PatchTaper*1))+(cOver*-1))+(W50*0)), (((((0mm+(dy*-0.5))*1)+(((Lp*0.5)*-1)-feedRise))+(cOver*0))+(W50*0.5))), closed, covered)
  Branch_0011_50PT_Taper.thicken(tCu)
  Branch_0011_PT = polyline(z=h+tCu/2, xy: (((((0mm+(dx*-0.5))*1)-((LpT-feedRise)*1))+(cOver*-1)), ((((0mm+(dy*-0.5))*1)+(((Lp*0.5)*-1)-feedRise))+(cOver*0))) (((0mm+(dx*-0.5))*1), (((0mm+(dy*-0.5))*1)+(((Lp*0.5)*-1)-feedRise))) ((((0mm+(dx*-0.5))*1)+(cOver*0)), (((dy*-0.5)-(Lp*0.5))+(cOver*1))), section rectangle width=WpT height=tCu bend_type=Curved)
  Branch_01_Q = box(corner=(((((((0mm+(dx*-1.5))+(dx*-0.5))+(dx*0.5))+(dx*1.5))*0.25)+(cOver*-1)), (((((0mm+(dy*-1.5))+(dy*-0.5))*0.5)+(((Lp*0.5)*-1)-feedRise))-(W70*0.5)), h), size=(((((((((0mm+(dx*-1.5))+(dx*-0.5))+(dx*0.5))+(dx*1.5))*0.25)+(Lq2*1))+(cOver*1))-((((((0mm+(dx*-1.5))+(dx*-0.5))+(dx*0.5))+(dx*1.5))*0.25)+(cOver*-1))), W70, tCu))
  Branch_01_Q50_Taper = polyline(z=h, xy: (((((((((0mm+(dx*-1.5))+(dx*-0.5))+(dx*0.5))+(dx*1.5))*0.25)+(Lq2*1))+(cOver*-0.7071067812))-(W70*-0.3535533906)), ((((((0mm+(dy*-1.5))+(dy*-0.5))*0.5)+(((Lp*0.5)*-1)-feedRise))+(cOver*-0.7071067812))-(W70*0.3535533906))) ((((((((((0mm+(dx*-1.5))+(dx*-0.5))+(dx*0.5))+(dx*1.5))*0.25)+(Lq2*1))+(Lq50Taper*0.7071067812))+(cOver*0.7071067812))-(W50*-0.3535533906)), (((((((0mm+(dy*-1.5))+(dy*-0.5))*0.5)+(((Lp*0.5)*-1)-feedRise))+(Lq50Taper*0.7071067812))+(cOver*0.7071067812))-(W50*0.3535533906))) ((((((((((0mm+(dx*-1.5))+(dx*-0.5))+(dx*0.5))+(dx*1.5))*0.25)+(Lq2*1))+(Lq50Taper*0.7071067812))+(cOver*0.7071067812))+(W50*-0.3535533906)), (((((((0mm+(dy*-1.5))+(dy*-0.5))*0.5)+(((Lp*0.5)*-1)-feedRise))+(Lq50Taper*0.7071067812))+(cOver*0.7071067812))+(W50*0.3535533906))) (((((((((0mm+(dx*-1.5))+(dx*-0.5))+(dx*0.5))+(dx*1.5))*0.25)+(Lq2*1))+(cOver*-0.7071067812))+(W70*-0.3535533906)), ((((((0mm+(dy*-1.5))+(dy*-0.5))*0.5)+(((Lp*0.5)*-1)-feedRise))+(cOver*-0.7071067812))+(W70*0.3535533906))), closed, covered)
  Branch_01_Q50_Taper.thicken(tCu)
  Branch_01_BendFill = cylinder(axis=Z, base_centre=(((((((0mm+(dx*-1.5))+(dx*-0.5))+(dx*0.5))+(dx*1.5))*0.25)+(Lq2*1)), ((((0mm+(dy*-1.5))+(dy*-0.5))*0.5)+(((Lp*0.5)*-1)-feedRise)), h), radius=(W70*0.62), height=tCu)
  Branch_01_50_Clearance = polyline(z=h+tCu/2, xy: (((((((((0mm+(dx*-1.5))+(dx*-0.5))+(dx*0.5))+(dx*1.5))*0.25)+(Lq2*1))+(Lq50Taper*0.7071067812))+(cOver*-0.7071067812)), ((((((0mm+(dy*-1.5))+(dy*-0.5))*0.5)+(((Lp*0.5)*-1)-feedRise))+(Lq50Taper*0.7071067812))+(cOver*-0.7071067812))) ((((((((0mm+(dx*-1.5))+(dx*-0.5))+(dx*0.5))+(dx*1.5))*0.25)+(Lq2*1))+(((Lp*0.5)+feedRise)*1)), (((((0mm+(dy*-1.5))+(dy*-0.5))*0.5)+(((Lp*0.5)*-1)-feedRise))+((Lp*0.5)+feedRise))) ((((((0mm+(dx*0.5))+(dx*1.5))*0.5)-(teeApproach*1))-(((Lp*0.5)+feedRise)*1)), (((((0mm+(dy*-1.5))+(dy*-0.5))*0.5)+(((Lp*0.5)*-1)-feedRise))+((Lp*0.5)+feedRise))) (((((0mm+(dx*0.5))+(dx*1.5))*0.5)-(teeApproach*1)), ((((0mm+(dy*-1.5))+(dy*-0.5))*0.5)+(((Lp*0.5)*-1)-feedRise))) (((((0mm+(dx*0.5))+(dx*1.5))*0.5)+(cOver*1)), (((((0mm+(dy*-1.5))+(dy*-0.5))*0.5)+(((Lp*0.5)*-1)-feedRise))+(cOver*0))), section rectangle width=W50 height=tCu bend_type=Curved)
  RoundTee_01 = cylinder(axis=Z, base_centre=((((0mm+(dx*0.5))+(dx*1.5))*0.5), ((((0mm+(dy*-1.5))+(dy*-0.5))*0.5)+(((Lp*0.5)*-1)-feedRise)), h), radius=junctionR, height=tCu)
  Branch_010_Q = box(corner=(((((0mm+(dx*0.5))+(dx*1.5))*0.5)-(W70*0.5)), ((((((0mm+(dy*-1.5))+(dy*-0.5))*0.5)+(((Lp*0.5)*-1)-feedRise))+(Lq3*-1))+(cOver*-1)), h), size=(W70, ((((((0mm+(dy*-1.5))+(dy*-0.5))*0.5)+(((Lp*0.5)*-1)-feedRise))+(cOver*1))-((((((0mm+(dy*-1.5))+(dy*-0.5))*0.5)+(((Lp*0.5)*-1)-feedRise))+(Lq3*-1))+(cOver*-1))), tCu))
  Branch_010_Q50_Taper = polyline(z=h, xy: ((((((0mm+(dx*0.5))+(dx*1.5))*0.5)+(cOver*0))-(W70*0.5)), (((((((0mm+(dy*-1.5))+(dy*-0.5))*0.5)+(((Lp*0.5)*-1)-feedRise))+(Lq3*-1))+(cOver*1))-(W70*0))) ((((((0mm+(dx*0.5))+(dx*1.5))*0.5)+(cOver*0))-(W50*0.5)), ((((((((0mm+(dy*-1.5))+(dy*-0.5))*0.5)+(((Lp*0.5)*-1)-feedRise))+(Lq3*-1))+(Lq50Taper*-1))+(cOver*-1))-(W50*0))) ((((((0mm+(dx*0.5))+(dx*1.5))*0.5)+(cOver*0))+(W50*0.5)), ((((((((0mm+(dy*-1.5))+(dy*-0.5))*0.5)+(((Lp*0.5)*-1)-feedRise))+(Lq3*-1))+(Lq50Taper*-1))+(cOver*-1))+(W50*0))) ((((((0mm+(dx*0.5))+(dx*1.5))*0.5)+(cOver*0))+(W70*0.5)), (((((((0mm+(dy*-1.5))+(dy*-0.5))*0.5)+(((Lp*0.5)*-1)-feedRise))+(Lq3*-1))+(cOver*1))+(W70*0))), closed, covered)
  Branch_010_Q50_Taper.thicken(tCu)
  Branch_010_50 = box(corner=(((((0mm+(dx*0.5))+(dx*1.5))*0.5)-(W50*0.5)), ((((0mm+(dy*-1.5))*1)+(((Lp*0.5)*-1)-feedRise))+(cOver*-1)), h), size=(W50, ((((((((0mm+(dy*-1.5))+(dy*-0.5))*0.5)+(((Lp*0.5)*-1)-feedRise))+(Lq3*-1))+(Lq50Taper*-1))+(cOver*1))-((((0mm+(dy*-1.5))*1)+(((Lp*0.5)*-1)-feedRise))+(cOver*-1))), tCu))
  RoundTee_010 = cylinder(axis=Z, base_centre=((((0mm+(dx*0.5))+(dx*1.5))*0.5), (((0mm+(dy*-1.5))*1)+(((Lp*0.5)*-1)-feedRise)), h), radius=junctionR, height=tCu)
  Patch_r1_c3 = box(corner=(((dx*0.5)-(Wp*0.5)), ((dy*-1.5)-(Lp*0.5)), h), size=(Wp, Lp, tCu))
  Branch_0100_Q = box(corner=((((((0mm+(dx*0.5))+(dx*1.5))*0.5)+(Lq4*-1))+(cOver*-1)), ((((0mm+(dy*-1.5))*1)+(((Lp*0.5)*-1)-feedRise))-(W70*0.5)), h), size=((((((0mm+(dx*0.5))+(dx*1.5))*0.5)+(cOver*1))-(((((0mm+(dx*0.5))+(dx*1.5))*0.5)+(Lq4*-1))+(cOver*-1))), W70, tCu))
  Branch_0100_Q50_Taper = polyline(z=h, xy: (((((((0mm+(dx*0.5))+(dx*1.5))*0.5)+(Lq4*-1))+(cOver*1))-(W70*0)), (((((0mm+(dy*-1.5))*1)+(((Lp*0.5)*-1)-feedRise))+(cOver*0))-(W70*-0.5))) ((((((((0mm+(dx*0.5))+(dx*1.5))*0.5)+(Lq4*-1))+(Lq50Taper*-1))+(cOver*-1))-(W50*0)), (((((0mm+(dy*-1.5))*1)+(((Lp*0.5)*-1)-feedRise))+(cOver*0))-(W50*-0.5))) ((((((((0mm+(dx*0.5))+(dx*1.5))*0.5)+(Lq4*-1))+(Lq50Taper*-1))+(cOver*-1))+(W50*0)), (((((0mm+(dy*-1.5))*1)+(((Lp*0.5)*-1)-feedRise))+(cOver*0))+(W50*-0.5))) (((((((0mm+(dx*0.5))+(dx*1.5))*0.5)+(Lq4*-1))+(cOver*1))+(W70*0)), (((((0mm+(dy*-1.5))*1)+(((Lp*0.5)*-1)-feedRise))+(cOver*0))+(W70*-0.5))), closed, covered)
  Branch_0100_Q50_Taper.thicken(tCu)
  Branch_0100_50 = box(corner=((((((0mm+(dx*0.5))*1)-((LpT-feedRise)*-1))-(L50PatchTaper*-1))+(cOver*-1)), ((((0mm+(dy*-1.5))*1)+(((Lp*0.5)*-1)-feedRise))-(W50*0.5)), h), size=((((((((0mm+(dx*0.5))+(dx*1.5))*0.5)+(Lq4*-1))+(Lq50Taper*-1))+(cOver*1))-(((((0mm+(dx*0.5))*1)-((LpT-feedRise)*-1))-(L50PatchTaper*-1))+(cOver*-1))), W50, tCu))
  Branch_0100_50PT_Taper = polyline(z=h, xy: (((((((0mm+(dx*0.5))*1)-((LpT-feedRise)*-1))-(L50PatchTaper*-1))+(cOver*1))-(W50*0)), (((((0mm+(dy*-1.5))*1)+(((Lp*0.5)*-1)-feedRise))+(cOver*0))-(W50*-0.5))) ((((((0mm+(dx*0.5))*1)-((LpT-feedRise)*-1))+(cOver*-1))-(WpT*0)), (((((0mm+(dy*-1.5))*1)+(((Lp*0.5)*-1)-feedRise))+(cOver*0))-(WpT*-0.5))) ((((((0mm+(dx*0.5))*1)-((LpT-feedRise)*-1))+(cOver*-1))+(WpT*0)), (((((0mm+(dy*-1.5))*1)+(((Lp*0.5)*-1)-feedRise))+(cOver*0))+(WpT*-0.5))) (((((((0mm+(dx*0.5))*1)-((LpT-feedRise)*-1))-(L50PatchTaper*-1))+(cOver*1))+(W50*0)), (((((0mm+(dy*-1.5))*1)+(((Lp*0.5)*-1)-feedRise))+(cOver*0))+(W50*-0.5))), closed, covered)
  Branch_0100_50PT_Taper.thicken(tCu)
  Branch_0100_PT = polyline(z=h+tCu/2, xy: (((((0mm+(dx*0.5))*1)-((LpT-feedRise)*-1))+(cOver*1)), ((((0mm+(dy*-1.5))*1)+(((Lp*0.5)*-1)-feedRise))+(cOver*0))) (((0mm+(dx*0.5))*1), (((0mm+(dy*-1.5))*1)+(((Lp*0.5)*-1)-feedRise))) ((((0mm+(dx*0.5))*1)+(cOver*0)), (((dy*-1.5)-(Lp*0.5))+(cOver*1))), section rectangle width=WpT height=tCu bend_type=Curved)
  Patch_r1_c4 = box(corner=(((dx*1.5)-(Wp*0.5)), ((dy*-1.5)-(Lp*0.5)), h), size=(Wp, Lp, tCu))
  Branch_0101_Q = box(corner=(((((0mm+(dx*0.5))+(dx*1.5))*0.5)+(cOver*-1)), ((((0mm+(dy*-1.5))*1)+(((Lp*0.5)*-1)-feedRise))-(W70*0.5)), h), size=(((((((0mm+(dx*0.5))+(dx*1.5))*0.5)+(Lq4*1))+(cOver*1))-((((0mm+(dx*0.5))+(dx*1.5))*0.5)+(cOver*-1))), W70, tCu))
  Branch_0101_Q50_Taper = polyline(z=h, xy: (((((((0mm+(dx*0.5))+(dx*1.5))*0.5)+(Lq4*1))+(cOver*-1))-(W70*0)), (((((0mm+(dy*-1.5))*1)+(((Lp*0.5)*-1)-feedRise))+(cOver*0))-(W70*0.5))) ((((((((0mm+(dx*0.5))+(dx*1.5))*0.5)+(Lq4*1))+(Lq50Taper*1))+(cOver*1))-(W50*0)), (((((0mm+(dy*-1.5))*1)+(((Lp*0.5)*-1)-feedRise))+(cOver*0))-(W50*0.5))) ((((((((0mm+(dx*0.5))+(dx*1.5))*0.5)+(Lq4*1))+(Lq50Taper*1))+(cOver*1))+(W50*0)), (((((0mm+(dy*-1.5))*1)+(((Lp*0.5)*-1)-feedRise))+(cOver*0))+(W50*0.5))) (((((((0mm+(dx*0.5))+(dx*1.5))*0.5)+(Lq4*1))+(cOver*-1))+(W70*0)), (((((0mm+(dy*-1.5))*1)+(((Lp*0.5)*-1)-feedRise))+(cOver*0))+(W70*0.5))), closed, covered)
  Branch_0101_Q50_Taper.thicken(tCu)
  Branch_0101_50 = box(corner=(((((((0mm+(dx*0.5))+(dx*1.5))*0.5)+(Lq4*1))+(Lq50Taper*1))+(cOver*-1)), ((((0mm+(dy*-1.5))*1)+(((Lp*0.5)*-1)-feedRise))-(W50*0.5)), h), size=(((((((0mm+(dx*1.5))*1)-((LpT-feedRise)*1))-(L50PatchTaper*1))+(cOver*1))-((((((0mm+(dx*0.5))+(dx*1.5))*0.5)+(Lq4*1))+(Lq50Taper*1))+(cOver*-1))), W50, tCu))
  Branch_0101_50PT_Taper = polyline(z=h, xy: (((((((0mm+(dx*1.5))*1)-((LpT-feedRise)*1))-(L50PatchTaper*1))+(cOver*-1))-(W50*0)), (((((0mm+(dy*-1.5))*1)+(((Lp*0.5)*-1)-feedRise))+(cOver*0))-(W50*0.5))) ((((((0mm+(dx*1.5))*1)-((LpT-feedRise)*1))+(cOver*1))-(WpT*0)), (((((0mm+(dy*-1.5))*1)+(((Lp*0.5)*-1)-feedRise))+(cOver*0))-(WpT*0.5))) ((((((0mm+(dx*1.5))*1)-((LpT-feedRise)*1))+(cOver*1))+(WpT*0)), (((((0mm+(dy*-1.5))*1)+(((Lp*0.5)*-1)-feedRise))+(cOver*0))+(WpT*0.5))) (((((((0mm+(dx*1.5))*1)-((LpT-feedRise)*1))-(L50PatchTaper*1))+(cOver*-1))+(W50*0)), (((((0mm+(dy*-1.5))*1)+(((Lp*0.5)*-1)-feedRise))+(cOver*0))+(W50*0.5))), closed, covered)
  Branch_0101_50PT_Taper.thicken(tCu)
  Branch_0101_PT = polyline(z=h+tCu/2, xy: (((((0mm+(dx*1.5))*1)-((LpT-feedRise)*1))+(cOver*-1)), ((((0mm+(dy*-1.5))*1)+(((Lp*0.5)*-1)-feedRise))+(cOver*0))) (((0mm+(dx*1.5))*1), (((0mm+(dy*-1.5))*1)+(((Lp*0.5)*-1)-feedRise))) ((((0mm+(dx*1.5))*1)+(cOver*0)), (((dy*-1.5)-(Lp*0.5))+(cOver*1))), section rectangle width=WpT height=tCu bend_type=Curved)
  Branch_011_Q = box(corner=(((((0mm+(dx*0.5))+(dx*1.5))*0.5)-(W70*0.5)), (((((0mm+(dy*-1.5))+(dy*-0.5))*0.5)+(((Lp*0.5)*-1)-feedRise))+(cOver*-1)), h), size=(W70, (((((((0mm+(dy*-1.5))+(dy*-0.5))*0.5)+(((Lp*0.5)*-1)-feedRise))+(Lq3*1))+(cOver*1))-(((((0mm+(dy*-1.5))+(dy*-0.5))*0.5)+(((Lp*0.5)*-1)-feedRise))+(cOver*-1))), tCu))
  Branch_011_Q50_Taper = polyline(z=h, xy: ((((((0mm+(dx*0.5))+(dx*1.5))*0.5)+(cOver*0))-(W70*-0.5)), (((((((0mm+(dy*-1.5))+(dy*-0.5))*0.5)+(((Lp*0.5)*-1)-feedRise))+(Lq3*1))+(cOver*-1))-(W70*0))) ((((((0mm+(dx*0.5))+(dx*1.5))*0.5)+(cOver*0))-(W50*-0.5)), ((((((((0mm+(dy*-1.5))+(dy*-0.5))*0.5)+(((Lp*0.5)*-1)-feedRise))+(Lq3*1))+(Lq50Taper*1))+(cOver*1))-(W50*0))) ((((((0mm+(dx*0.5))+(dx*1.5))*0.5)+(cOver*0))+(W50*-0.5)), ((((((((0mm+(dy*-1.5))+(dy*-0.5))*0.5)+(((Lp*0.5)*-1)-feedRise))+(Lq3*1))+(Lq50Taper*1))+(cOver*1))+(W50*0))) ((((((0mm+(dx*0.5))+(dx*1.5))*0.5)+(cOver*0))+(W70*-0.5)), (((((((0mm+(dy*-1.5))+(dy*-0.5))*0.5)+(((Lp*0.5)*-1)-feedRise))+(Lq3*1))+(cOver*-1))+(W70*0))), closed, covered)
  Branch_011_Q50_Taper.thicken(tCu)
  Branch_011_50 = box(corner=(((((0mm+(dx*0.5))+(dx*1.5))*0.5)-(W50*0.5)), (((((((0mm+(dy*-1.5))+(dy*-0.5))*0.5)+(((Lp*0.5)*-1)-feedRise))+(Lq3*1))+(Lq50Taper*1))+(cOver*-1)), h), size=(W50, (((((0mm+(dy*-0.5))*1)+(((Lp*0.5)*-1)-feedRise))+(cOver*1))-(((((((0mm+(dy*-1.5))+(dy*-0.5))*0.5)+(((Lp*0.5)*-1)-feedRise))+(Lq3*1))+(Lq50Taper*1))+(cOver*-1))), tCu))
  RoundTee_011 = cylinder(axis=Z, base_centre=((((0mm+(dx*0.5))+(dx*1.5))*0.5), (((0mm+(dy*-0.5))*1)+(((Lp*0.5)*-1)-feedRise)), h), radius=junctionR, height=tCu)
  Patch_r2_c3 = box(corner=(((dx*0.5)-(Wp*0.5)), ((dy*-0.5)-(Lp*0.5)), h), size=(Wp, Lp, tCu))
  Branch_0110_Q = box(corner=((((((0mm+(dx*0.5))+(dx*1.5))*0.5)+(Lq4*-1))+(cOver*-1)), ((((0mm+(dy*-0.5))*1)+(((Lp*0.5)*-1)-feedRise))-(W70*0.5)), h), size=((((((0mm+(dx*0.5))+(dx*1.5))*0.5)+(cOver*1))-(((((0mm+(dx*0.5))+(dx*1.5))*0.5)+(Lq4*-1))+(cOver*-1))), W70, tCu))
  Branch_0110_Q50_Taper = polyline(z=h, xy: (((((((0mm+(dx*0.5))+(dx*1.5))*0.5)+(Lq4*-1))+(cOver*1))-(W70*0)), (((((0mm+(dy*-0.5))*1)+(((Lp*0.5)*-1)-feedRise))+(cOver*0))-(W70*-0.5))) ((((((((0mm+(dx*0.5))+(dx*1.5))*0.5)+(Lq4*-1))+(Lq50Taper*-1))+(cOver*-1))-(W50*0)), (((((0mm+(dy*-0.5))*1)+(((Lp*0.5)*-1)-feedRise))+(cOver*0))-(W50*-0.5))) ((((((((0mm+(dx*0.5))+(dx*1.5))*0.5)+(Lq4*-1))+(Lq50Taper*-1))+(cOver*-1))+(W50*0)), (((((0mm+(dy*-0.5))*1)+(((Lp*0.5)*-1)-feedRise))+(cOver*0))+(W50*-0.5))) (((((((0mm+(dx*0.5))+(dx*1.5))*0.5)+(Lq4*-1))+(cOver*1))+(W70*0)), (((((0mm+(dy*-0.5))*1)+(((Lp*0.5)*-1)-feedRise))+(cOver*0))+(W70*-0.5))), closed, covered)
  Branch_0110_Q50_Taper.thicken(tCu)
  Branch_0110_50 = box(corner=((((((0mm+(dx*0.5))*1)-((LpT-feedRise)*-1))-(L50PatchTaper*-1))+(cOver*-1)), ((((0mm+(dy*-0.5))*1)+(((Lp*0.5)*-1)-feedRise))-(W50*0.5)), h), size=((((((((0mm+(dx*0.5))+(dx*1.5))*0.5)+(Lq4*-1))+(Lq50Taper*-1))+(cOver*1))-(((((0mm+(dx*0.5))*1)-((LpT-feedRise)*-1))-(L50PatchTaper*-1))+(cOver*-1))), W50, tCu))
  Branch_0110_50PT_Taper = polyline(z=h, xy: (((((((0mm+(dx*0.5))*1)-((LpT-feedRise)*-1))-(L50PatchTaper*-1))+(cOver*1))-(W50*0)), (((((0mm+(dy*-0.5))*1)+(((Lp*0.5)*-1)-feedRise))+(cOver*0))-(W50*-0.5))) ((((((0mm+(dx*0.5))*1)-((LpT-feedRise)*-1))+(cOver*-1))-(WpT*0)), (((((0mm+(dy*-0.5))*1)+(((Lp*0.5)*-1)-feedRise))+(cOver*0))-(WpT*-0.5))) ((((((0mm+(dx*0.5))*1)-((LpT-feedRise)*-1))+(cOver*-1))+(WpT*0)), (((((0mm+(dy*-0.5))*1)+(((Lp*0.5)*-1)-feedRise))+(cOver*0))+(WpT*-0.5))) (((((((0mm+(dx*0.5))*1)-((LpT-feedRise)*-1))-(L50PatchTaper*-1))+(cOver*1))+(W50*0)), (((((0mm+(dy*-0.5))*1)+(((Lp*0.5)*-1)-feedRise))+(cOver*0))+(W50*-0.5))), closed, covered)
  Branch_0110_50PT_Taper.thicken(tCu)
  Branch_0110_PT = polyline(z=h+tCu/2, xy: (((((0mm+(dx*0.5))*1)-((LpT-feedRise)*-1))+(cOver*1)), ((((0mm+(dy*-0.5))*1)+(((Lp*0.5)*-1)-feedRise))+(cOver*0))) (((0mm+(dx*0.5))*1), (((0mm+(dy*-0.5))*1)+(((Lp*0.5)*-1)-feedRise))) ((((0mm+(dx*0.5))*1)+(cOver*0)), (((dy*-0.5)-(Lp*0.5))+(cOver*1))), section rectangle width=WpT height=tCu bend_type=Curved)
  Patch_r2_c4 = box(corner=(((dx*1.5)-(Wp*0.5)), ((dy*-0.5)-(Lp*0.5)), h), size=(Wp, Lp, tCu))
  Branch_0111_Q = box(corner=(((((0mm+(dx*0.5))+(dx*1.5))*0.5)+(cOver*-1)), ((((0mm+(dy*-0.5))*1)+(((Lp*0.5)*-1)-feedRise))-(W70*0.5)), h), size=(((((((0mm+(dx*0.5))+(dx*1.5))*0.5)+(Lq4*1))+(cOver*1))-((((0mm+(dx*0.5))+(dx*1.5))*0.5)+(cOver*-1))), W70, tCu))
  Branch_0111_Q50_Taper = polyline(z=h, xy: (((((((0mm+(dx*0.5))+(dx*1.5))*0.5)+(Lq4*1))+(cOver*-1))-(W70*0)), (((((0mm+(dy*-0.5))*1)+(((Lp*0.5)*-1)-feedRise))+(cOver*0))-(W70*0.5))) ((((((((0mm+(dx*0.5))+(dx*1.5))*0.5)+(Lq4*1))+(Lq50Taper*1))+(cOver*1))-(W50*0)), (((((0mm+(dy*-0.5))*1)+(((Lp*0.5)*-1)-feedRise))+(cOver*0))-(W50*0.5))) ((((((((0mm+(dx*0.5))+(dx*1.5))*0.5)+(Lq4*1))+(Lq50Taper*1))+(cOver*1))+(W50*0)), (((((0mm+(dy*-0.5))*1)+(((Lp*0.5)*-1)-feedRise))+(cOver*0))+(W50*0.5))) (((((((0mm+(dx*0.5))+(dx*1.5))*0.5)+(Lq4*1))+(cOver*-1))+(W70*0)), (((((0mm+(dy*-0.5))*1)+(((Lp*0.5)*-1)-feedRise))+(cOver*0))+(W70*0.5))), closed, covered)
  Branch_0111_Q50_Taper.thicken(tCu)
  Branch_0111_50 = box(corner=(((((((0mm+(dx*0.5))+(dx*1.5))*0.5)+(Lq4*1))+(Lq50Taper*1))+(cOver*-1)), ((((0mm+(dy*-0.5))*1)+(((Lp*0.5)*-1)-feedRise))-(W50*0.5)), h), size=(((((((0mm+(dx*1.5))*1)-((LpT-feedRise)*1))-(L50PatchTaper*1))+(cOver*1))-((((((0mm+(dx*0.5))+(dx*1.5))*0.5)+(Lq4*1))+(Lq50Taper*1))+(cOver*-1))), W50, tCu))
  Branch_0111_50PT_Taper = polyline(z=h, xy: (((((((0mm+(dx*1.5))*1)-((LpT-feedRise)*1))-(L50PatchTaper*1))+(cOver*-1))-(W50*0)), (((((0mm+(dy*-0.5))*1)+(((Lp*0.5)*-1)-feedRise))+(cOver*0))-(W50*0.5))) ((((((0mm+(dx*1.5))*1)-((LpT-feedRise)*1))+(cOver*1))-(WpT*0)), (((((0mm+(dy*-0.5))*1)+(((Lp*0.5)*-1)-feedRise))+(cOver*0))-(WpT*0.5))) ((((((0mm+(dx*1.5))*1)-((LpT-feedRise)*1))+(cOver*1))+(WpT*0)), (((((0mm+(dy*-0.5))*1)+(((Lp*0.5)*-1)-feedRise))+(cOver*0))+(WpT*0.5))) (((((((0mm+(dx*1.5))*1)-((LpT-feedRise)*1))-(L50PatchTaper*1))+(cOver*-1))+(W50*0)), (((((0mm+(dy*-0.5))*1)+(((Lp*0.5)*-1)-feedRise))+(cOver*0))+(W50*0.5))), closed, covered)
  Branch_0111_50PT_Taper.thicken(tCu)
  Branch_0111_PT = polyline(z=h+tCu/2, xy: (((((0mm+(dx*1.5))*1)-((LpT-feedRise)*1))+(cOver*-1)), ((((0mm+(dy*-0.5))*1)+(((Lp*0.5)*-1)-feedRise))+(cOver*0))) (((0mm+(dx*1.5))*1), (((0mm+(dy*-0.5))*1)+(((Lp*0.5)*-1)-feedRise))) ((((0mm+(dx*1.5))*1)+(cOver*0)), (((dy*-0.5)-(Lp*0.5))+(cOver*1))), section rectangle width=WpT height=tCu bend_type=Curved)
  Branch_1_Q = box(corner=(((((((0mm+(dx*-1.5))+(dx*-0.5))+(dx*0.5))+(dx*1.5))*0.25)-(W70*0.5)), (((((((0mm+(dy*-1.5))+(dy*-0.5))+(dy*0.5))+(dy*1.5))*0.25)+(((Lp*0.5)*-1)-feedRise))+(cOver*-1)), h), size=(W70, (((((((((0mm+(dy*-1.5))+(dy*-0.5))+(dy*0.5))+(dy*1.5))*0.25)+(((Lp*0.5)*-1)-feedRise))+(Lq1*1))+(cOver*1))-(((((((0mm+(dy*-1.5))+(dy*-0.5))+(dy*0.5))+(dy*1.5))*0.25)+(((Lp*0.5)*-1)-feedRise))+(cOver*-1))), tCu))
  Branch_1_Q50_Taper = polyline(z=h, xy: ((((((((0mm+(dx*-1.5))+(dx*-0.5))+(dx*0.5))+(dx*1.5))*0.25)+(cOver*0))-(W70*-0.5)), (((((((((0mm+(dy*-1.5))+(dy*-0.5))+(dy*0.5))+(dy*1.5))*0.25)+(((Lp*0.5)*-1)-feedRise))+(Lq1*1))+(cOver*-1))-(W70*0))) ((((((((0mm+(dx*-1.5))+(dx*-0.5))+(dx*0.5))+(dx*1.5))*0.25)+(cOver*0))-(W50*-0.5)), ((((((((((0mm+(dy*-1.5))+(dy*-0.5))+(dy*0.5))+(dy*1.5))*0.25)+(((Lp*0.5)*-1)-feedRise))+(Lq1*1))+(Lq50Taper*1))+(cOver*1))-(W50*0))) ((((((((0mm+(dx*-1.5))+(dx*-0.5))+(dx*0.5))+(dx*1.5))*0.25)+(cOver*0))+(W50*-0.5)), ((((((((((0mm+(dy*-1.5))+(dy*-0.5))+(dy*0.5))+(dy*1.5))*0.25)+(((Lp*0.5)*-1)-feedRise))+(Lq1*1))+(Lq50Taper*1))+(cOver*1))+(W50*0))) ((((((((0mm+(dx*-1.5))+(dx*-0.5))+(dx*0.5))+(dx*1.5))*0.25)+(cOver*0))+(W70*-0.5)), (((((((((0mm+(dy*-1.5))+(dy*-0.5))+(dy*0.5))+(dy*1.5))*0.25)+(((Lp*0.5)*-1)-feedRise))+(Lq1*1))+(cOver*-1))+(W70*0))), closed, covered)
  Branch_1_Q50_Taper.thicken(tCu)
  Branch_1_50 = box(corner=(((((((0mm+(dx*-1.5))+(dx*-0.5))+(dx*0.5))+(dx*1.5))*0.25)-(W50*0.5)), (((((((((0mm+(dy*-1.5))+(dy*-0.5))+(dy*0.5))+(dy*1.5))*0.25)+(((Lp*0.5)*-1)-feedRise))+(Lq1*1))+(Lq50Taper*1))+(cOver*-1)), h), size=(W50, ((((((0mm+(dy*0.5))+(dy*1.5))*0.5)+(((Lp*0.5)*-1)-feedRise))+(cOver*1))-(((((((((0mm+(dy*-1.5))+(dy*-0.5))+(dy*0.5))+(dy*1.5))*0.25)+(((Lp*0.5)*-1)-feedRise))+(Lq1*1))+(Lq50Taper*1))+(cOver*-1))), tCu))
  RoundTee_1 = cylinder(axis=Z, base_centre=((((((0mm+(dx*-1.5))+(dx*-0.5))+(dx*0.5))+(dx*1.5))*0.25), ((((0mm+(dy*0.5))+(dy*1.5))*0.5)+(((Lp*0.5)*-1)-feedRise)), h), radius=junctionR, height=tCu)
  Branch_10_Q = box(corner=((((((((0mm+(dx*-1.5))+(dx*-0.5))+(dx*0.5))+(dx*1.5))*0.25)+(Lq2*-1))+(cOver*-1)), (((((0mm+(dy*0.5))+(dy*1.5))*0.5)+(((Lp*0.5)*-1)-feedRise))-(W70*0.5)), h), size=((((((((0mm+(dx*-1.5))+(dx*-0.5))+(dx*0.5))+(dx*1.5))*0.25)+(cOver*1))-(((((((0mm+(dx*-1.5))+(dx*-0.5))+(dx*0.5))+(dx*1.5))*0.25)+(Lq2*-1))+(cOver*-1))), W70, tCu))
  Branch_10_Q50_Taper = polyline(z=h, xy: (((((((((0mm+(dx*-1.5))+(dx*-0.5))+(dx*0.5))+(dx*1.5))*0.25)+(Lq2*-1))+(cOver*0.7071067812))-(W70*-0.3535533906)), ((((((0mm+(dy*0.5))+(dy*1.5))*0.5)+(((Lp*0.5)*-1)-feedRise))+(cOver*-0.7071067812))-(W70*-0.3535533906))) ((((((((((0mm+(dx*-1.5))+(dx*-0.5))+(dx*0.5))+(dx*1.5))*0.25)+(Lq2*-1))+(Lq50Taper*-0.7071067812))+(cOver*-0.7071067812))-(W50*-0.3535533906)), (((((((0mm+(dy*0.5))+(dy*1.5))*0.5)+(((Lp*0.5)*-1)-feedRise))+(Lq50Taper*0.7071067812))+(cOver*0.7071067812))-(W50*-0.3535533906))) ((((((((((0mm+(dx*-1.5))+(dx*-0.5))+(dx*0.5))+(dx*1.5))*0.25)+(Lq2*-1))+(Lq50Taper*-0.7071067812))+(cOver*-0.7071067812))+(W50*-0.3535533906)), (((((((0mm+(dy*0.5))+(dy*1.5))*0.5)+(((Lp*0.5)*-1)-feedRise))+(Lq50Taper*0.7071067812))+(cOver*0.7071067812))+(W50*-0.3535533906))) (((((((((0mm+(dx*-1.5))+(dx*-0.5))+(dx*0.5))+(dx*1.5))*0.25)+(Lq2*-1))+(cOver*0.7071067812))+(W70*-0.3535533906)), ((((((0mm+(dy*0.5))+(dy*1.5))*0.5)+(((Lp*0.5)*-1)-feedRise))+(cOver*-0.7071067812))+(W70*-0.3535533906))), closed, covered)
  Branch_10_Q50_Taper.thicken(tCu)
  Branch_10_BendFill = cylinder(axis=Z, base_centre=(((((((0mm+(dx*-1.5))+(dx*-0.5))+(dx*0.5))+(dx*1.5))*0.25)+(Lq2*-1)), ((((0mm+(dy*0.5))+(dy*1.5))*0.5)+(((Lp*0.5)*-1)-feedRise)), h), radius=(W70*0.62), height=tCu)
  Branch_10_50_Clearance = polyline(z=h+tCu/2, xy: (((((((((0mm+(dx*-1.5))+(dx*-0.5))+(dx*0.5))+(dx*1.5))*0.25)+(Lq2*-1))+(Lq50Taper*-0.7071067812))+(cOver*0.7071067812)), ((((((0mm+(dy*0.5))+(dy*1.5))*0.5)+(((Lp*0.5)*-1)-feedRise))+(Lq50Taper*0.7071067812))+(cOver*-0.7071067812))) ((((((((0mm+(dx*-1.5))+(dx*-0.5))+(dx*0.5))+(dx*1.5))*0.25)+(Lq2*-1))+(((Lp*0.5)+feedRise)*-1)), (((((0mm+(dy*0.5))+(dy*1.5))*0.5)+(((Lp*0.5)*-1)-feedRise))+((Lp*0.5)+feedRise))) ((((((0mm+(dx*-1.5))+(dx*-0.5))*0.5)-(teeApproach*-1))-(((Lp*0.5)+feedRise)*-1)), (((((0mm+(dy*0.5))+(dy*1.5))*0.5)+(((Lp*0.5)*-1)-feedRise))+((Lp*0.5)+feedRise))) (((((0mm+(dx*-1.5))+(dx*-0.5))*0.5)-(teeApproach*-1)), ((((0mm+(dy*0.5))+(dy*1.5))*0.5)+(((Lp*0.5)*-1)-feedRise))) (((((0mm+(dx*-1.5))+(dx*-0.5))*0.5)+(cOver*-1)), (((((0mm+(dy*0.5))+(dy*1.5))*0.5)+(((Lp*0.5)*-1)-feedRise))+(cOver*0))), section rectangle width=W50 height=tCu bend_type=Curved)
  RoundTee_10 = cylinder(axis=Z, base_centre=((((0mm+(dx*-1.5))+(dx*-0.5))*0.5), ((((0mm+(dy*0.5))+(dy*1.5))*0.5)+(((Lp*0.5)*-1)-feedRise)), h), radius=junctionR, height=tCu)
  Branch_100_Q = box(corner=(((((0mm+(dx*-1.5))+(dx*-0.5))*0.5)-(W70*0.5)), ((((((0mm+(dy*0.5))+(dy*1.5))*0.5)+(((Lp*0.5)*-1)-feedRise))+(Lq3*-1))+(cOver*-1)), h), size=(W70, ((((((0mm+(dy*0.5))+(dy*1.5))*0.5)+(((Lp*0.5)*-1)-feedRise))+(cOver*1))-((((((0mm+(dy*0.5))+(dy*1.5))*0.5)+(((Lp*0.5)*-1)-feedRise))+(Lq3*-1))+(cOver*-1))), tCu))
  Branch_100_Q50_Taper = polyline(z=h, xy: ((((((0mm+(dx*-1.5))+(dx*-0.5))*0.5)+(cOver*0))-(W70*0.5)), (((((((0mm+(dy*0.5))+(dy*1.5))*0.5)+(((Lp*0.5)*-1)-feedRise))+(Lq3*-1))+(cOver*1))-(W70*0))) ((((((0mm+(dx*-1.5))+(dx*-0.5))*0.5)+(cOver*0))-(W50*0.5)), ((((((((0mm+(dy*0.5))+(dy*1.5))*0.5)+(((Lp*0.5)*-1)-feedRise))+(Lq3*-1))+(Lq50Taper*-1))+(cOver*-1))-(W50*0))) ((((((0mm+(dx*-1.5))+(dx*-0.5))*0.5)+(cOver*0))+(W50*0.5)), ((((((((0mm+(dy*0.5))+(dy*1.5))*0.5)+(((Lp*0.5)*-1)-feedRise))+(Lq3*-1))+(Lq50Taper*-1))+(cOver*-1))+(W50*0))) ((((((0mm+(dx*-1.5))+(dx*-0.5))*0.5)+(cOver*0))+(W70*0.5)), (((((((0mm+(dy*0.5))+(dy*1.5))*0.5)+(((Lp*0.5)*-1)-feedRise))+(Lq3*-1))+(cOver*1))+(W70*0))), closed, covered)
  Branch_100_Q50_Taper.thicken(tCu)
  Branch_100_50 = box(corner=(((((0mm+(dx*-1.5))+(dx*-0.5))*0.5)-(W50*0.5)), ((((0mm+(dy*0.5))*1)+(((Lp*0.5)*-1)-feedRise))+(cOver*-1)), h), size=(W50, ((((((((0mm+(dy*0.5))+(dy*1.5))*0.5)+(((Lp*0.5)*-1)-feedRise))+(Lq3*-1))+(Lq50Taper*-1))+(cOver*1))-((((0mm+(dy*0.5))*1)+(((Lp*0.5)*-1)-feedRise))+(cOver*-1))), tCu))
  RoundTee_100 = cylinder(axis=Z, base_centre=((((0mm+(dx*-1.5))+(dx*-0.5))*0.5), (((0mm+(dy*0.5))*1)+(((Lp*0.5)*-1)-feedRise)), h), radius=junctionR, height=tCu)
  Patch_r3_c1 = box(corner=(((dx*-1.5)-(Wp*0.5)), ((dy*0.5)-(Lp*0.5)), h), size=(Wp, Lp, tCu))
  Branch_1000_Q = box(corner=((((((0mm+(dx*-1.5))+(dx*-0.5))*0.5)+(Lq4*-1))+(cOver*-1)), ((((0mm+(dy*0.5))*1)+(((Lp*0.5)*-1)-feedRise))-(W70*0.5)), h), size=((((((0mm+(dx*-1.5))+(dx*-0.5))*0.5)+(cOver*1))-(((((0mm+(dx*-1.5))+(dx*-0.5))*0.5)+(Lq4*-1))+(cOver*-1))), W70, tCu))
  Branch_1000_Q50_Taper = polyline(z=h, xy: (((((((0mm+(dx*-1.5))+(dx*-0.5))*0.5)+(Lq4*-1))+(cOver*1))-(W70*0)), (((((0mm+(dy*0.5))*1)+(((Lp*0.5)*-1)-feedRise))+(cOver*0))-(W70*-0.5))) ((((((((0mm+(dx*-1.5))+(dx*-0.5))*0.5)+(Lq4*-1))+(Lq50Taper*-1))+(cOver*-1))-(W50*0)), (((((0mm+(dy*0.5))*1)+(((Lp*0.5)*-1)-feedRise))+(cOver*0))-(W50*-0.5))) ((((((((0mm+(dx*-1.5))+(dx*-0.5))*0.5)+(Lq4*-1))+(Lq50Taper*-1))+(cOver*-1))+(W50*0)), (((((0mm+(dy*0.5))*1)+(((Lp*0.5)*-1)-feedRise))+(cOver*0))+(W50*-0.5))) (((((((0mm+(dx*-1.5))+(dx*-0.5))*0.5)+(Lq4*-1))+(cOver*1))+(W70*0)), (((((0mm+(dy*0.5))*1)+(((Lp*0.5)*-1)-feedRise))+(cOver*0))+(W70*-0.5))), closed, covered)
  Branch_1000_Q50_Taper.thicken(tCu)
  Branch_1000_50 = box(corner=((((((0mm+(dx*-1.5))*1)-((LpT-feedRise)*-1))-(L50PatchTaper*-1))+(cOver*-1)), ((((0mm+(dy*0.5))*1)+(((Lp*0.5)*-1)-feedRise))-(W50*0.5)), h), size=((((((((0mm+(dx*-1.5))+(dx*-0.5))*0.5)+(Lq4*-1))+(Lq50Taper*-1))+(cOver*1))-(((((0mm+(dx*-1.5))*1)-((LpT-feedRise)*-1))-(L50PatchTaper*-1))+(cOver*-1))), W50, tCu))
  Branch_1000_50PT_Taper = polyline(z=h, xy: (((((((0mm+(dx*-1.5))*1)-((LpT-feedRise)*-1))-(L50PatchTaper*-1))+(cOver*1))-(W50*0)), (((((0mm+(dy*0.5))*1)+(((Lp*0.5)*-1)-feedRise))+(cOver*0))-(W50*-0.5))) ((((((0mm+(dx*-1.5))*1)-((LpT-feedRise)*-1))+(cOver*-1))-(WpT*0)), (((((0mm+(dy*0.5))*1)+(((Lp*0.5)*-1)-feedRise))+(cOver*0))-(WpT*-0.5))) ((((((0mm+(dx*-1.5))*1)-((LpT-feedRise)*-1))+(cOver*-1))+(WpT*0)), (((((0mm+(dy*0.5))*1)+(((Lp*0.5)*-1)-feedRise))+(cOver*0))+(WpT*-0.5))) (((((((0mm+(dx*-1.5))*1)-((LpT-feedRise)*-1))-(L50PatchTaper*-1))+(cOver*1))+(W50*0)), (((((0mm+(dy*0.5))*1)+(((Lp*0.5)*-1)-feedRise))+(cOver*0))+(W50*-0.5))), closed, covered)
  Branch_1000_50PT_Taper.thicken(tCu)
  Branch_1000_PT = polyline(z=h+tCu/2, xy: (((((0mm+(dx*-1.5))*1)-((LpT-feedRise)*-1))+(cOver*1)), ((((0mm+(dy*0.5))*1)+(((Lp*0.5)*-1)-feedRise))+(cOver*0))) (((0mm+(dx*-1.5))*1), (((0mm+(dy*0.5))*1)+(((Lp*0.5)*-1)-feedRise))) ((((0mm+(dx*-1.5))*1)+(cOver*0)), (((dy*0.5)-(Lp*0.5))+(cOver*1))), section rectangle width=WpT height=tCu bend_type=Curved)
  Patch_r3_c2 = box(corner=(((dx*-0.5)-(Wp*0.5)), ((dy*0.5)-(Lp*0.5)), h), size=(Wp, Lp, tCu))
  Branch_1001_Q = box(corner=(((((0mm+(dx*-1.5))+(dx*-0.5))*0.5)+(cOver*-1)), ((((0mm+(dy*0.5))*1)+(((Lp*0.5)*-1)-feedRise))-(W70*0.5)), h), size=(((((((0mm+(dx*-1.5))+(dx*-0.5))*0.5)+(Lq4*1))+(cOver*1))-((((0mm+(dx*-1.5))+(dx*-0.5))*0.5)+(cOver*-1))), W70, tCu))
  Branch_1001_Q50_Taper = polyline(z=h, xy: (((((((0mm+(dx*-1.5))+(dx*-0.5))*0.5)+(Lq4*1))+(cOver*-1))-(W70*0)), (((((0mm+(dy*0.5))*1)+(((Lp*0.5)*-1)-feedRise))+(cOver*0))-(W70*0.5))) ((((((((0mm+(dx*-1.5))+(dx*-0.5))*0.5)+(Lq4*1))+(Lq50Taper*1))+(cOver*1))-(W50*0)), (((((0mm+(dy*0.5))*1)+(((Lp*0.5)*-1)-feedRise))+(cOver*0))-(W50*0.5))) ((((((((0mm+(dx*-1.5))+(dx*-0.5))*0.5)+(Lq4*1))+(Lq50Taper*1))+(cOver*1))+(W50*0)), (((((0mm+(dy*0.5))*1)+(((Lp*0.5)*-1)-feedRise))+(cOver*0))+(W50*0.5))) (((((((0mm+(dx*-1.5))+(dx*-0.5))*0.5)+(Lq4*1))+(cOver*-1))+(W70*0)), (((((0mm+(dy*0.5))*1)+(((Lp*0.5)*-1)-feedRise))+(cOver*0))+(W70*0.5))), closed, covered)
  Branch_1001_Q50_Taper.thicken(tCu)
  Branch_1001_50 = box(corner=(((((((0mm+(dx*-1.5))+(dx*-0.5))*0.5)+(Lq4*1))+(Lq50Taper*1))+(cOver*-1)), ((((0mm+(dy*0.5))*1)+(((Lp*0.5)*-1)-feedRise))-(W50*0.5)), h), size=(((((((0mm+(dx*-0.5))*1)-((LpT-feedRise)*1))-(L50PatchTaper*1))+(cOver*1))-((((((0mm+(dx*-1.5))+(dx*-0.5))*0.5)+(Lq4*1))+(Lq50Taper*1))+(cOver*-1))), W50, tCu))
  Branch_1001_50PT_Taper = polyline(z=h, xy: (((((((0mm+(dx*-0.5))*1)-((LpT-feedRise)*1))-(L50PatchTaper*1))+(cOver*-1))-(W50*0)), (((((0mm+(dy*0.5))*1)+(((Lp*0.5)*-1)-feedRise))+(cOver*0))-(W50*0.5))) ((((((0mm+(dx*-0.5))*1)-((LpT-feedRise)*1))+(cOver*1))-(WpT*0)), (((((0mm+(dy*0.5))*1)+(((Lp*0.5)*-1)-feedRise))+(cOver*0))-(WpT*0.5))) ((((((0mm+(dx*-0.5))*1)-((LpT-feedRise)*1))+(cOver*1))+(WpT*0)), (((((0mm+(dy*0.5))*1)+(((Lp*0.5)*-1)-feedRise))+(cOver*0))+(WpT*0.5))) (((((((0mm+(dx*-0.5))*1)-((LpT-feedRise)*1))-(L50PatchTaper*1))+(cOver*-1))+(W50*0)), (((((0mm+(dy*0.5))*1)+(((Lp*0.5)*-1)-feedRise))+(cOver*0))+(W50*0.5))), closed, covered)
  Branch_1001_50PT_Taper.thicken(tCu)
  Branch_1001_PT = polyline(z=h+tCu/2, xy: (((((0mm+(dx*-0.5))*1)-((LpT-feedRise)*1))+(cOver*-1)), ((((0mm+(dy*0.5))*1)+(((Lp*0.5)*-1)-feedRise))+(cOver*0))) (((0mm+(dx*-0.5))*1), (((0mm+(dy*0.5))*1)+(((Lp*0.5)*-1)-feedRise))) ((((0mm+(dx*-0.5))*1)+(cOver*0)), (((dy*0.5)-(Lp*0.5))+(cOver*1))), section rectangle width=WpT height=tCu bend_type=Curved)
  Branch_101_Q = box(corner=(((((0mm+(dx*-1.5))+(dx*-0.5))*0.5)-(W70*0.5)), (((((0mm+(dy*0.5))+(dy*1.5))*0.5)+(((Lp*0.5)*-1)-feedRise))+(cOver*-1)), h), size=(W70, (((((((0mm+(dy*0.5))+(dy*1.5))*0.5)+(((Lp*0.5)*-1)-feedRise))+(Lq3*1))+(cOver*1))-(((((0mm+(dy*0.5))+(dy*1.5))*0.5)+(((Lp*0.5)*-1)-feedRise))+(cOver*-1))), tCu))
  Branch_101_Q50_Taper = polyline(z=h, xy: ((((((0mm+(dx*-1.5))+(dx*-0.5))*0.5)+(cOver*0))-(W70*-0.5)), (((((((0mm+(dy*0.5))+(dy*1.5))*0.5)+(((Lp*0.5)*-1)-feedRise))+(Lq3*1))+(cOver*-1))-(W70*0))) ((((((0mm+(dx*-1.5))+(dx*-0.5))*0.5)+(cOver*0))-(W50*-0.5)), ((((((((0mm+(dy*0.5))+(dy*1.5))*0.5)+(((Lp*0.5)*-1)-feedRise))+(Lq3*1))+(Lq50Taper*1))+(cOver*1))-(W50*0))) ((((((0mm+(dx*-1.5))+(dx*-0.5))*0.5)+(cOver*0))+(W50*-0.5)), ((((((((0mm+(dy*0.5))+(dy*1.5))*0.5)+(((Lp*0.5)*-1)-feedRise))+(Lq3*1))+(Lq50Taper*1))+(cOver*1))+(W50*0))) ((((((0mm+(dx*-1.5))+(dx*-0.5))*0.5)+(cOver*0))+(W70*-0.5)), (((((((0mm+(dy*0.5))+(dy*1.5))*0.5)+(((Lp*0.5)*-1)-feedRise))+(Lq3*1))+(cOver*-1))+(W70*0))), closed, covered)
  Branch_101_Q50_Taper.thicken(tCu)
  Branch_101_50 = box(corner=(((((0mm+(dx*-1.5))+(dx*-0.5))*0.5)-(W50*0.5)), (((((((0mm+(dy*0.5))+(dy*1.5))*0.5)+(((Lp*0.5)*-1)-feedRise))+(Lq3*1))+(Lq50Taper*1))+(cOver*-1)), h), size=(W50, (((((0mm+(dy*1.5))*1)+(((Lp*0.5)*-1)-feedRise))+(cOver*1))-(((((((0mm+(dy*0.5))+(dy*1.5))*0.5)+(((Lp*0.5)*-1)-feedRise))+(Lq3*1))+(Lq50Taper*1))+(cOver*-1))), tCu))
  RoundTee_101 = cylinder(axis=Z, base_centre=((((0mm+(dx*-1.5))+(dx*-0.5))*0.5), (((0mm+(dy*1.5))*1)+(((Lp*0.5)*-1)-feedRise)), h), radius=junctionR, height=tCu)
  Patch_r4_c1 = box(corner=(((dx*-1.5)-(Wp*0.5)), ((dy*1.5)-(Lp*0.5)), h), size=(Wp, Lp, tCu))
  Branch_1010_Q = box(corner=((((((0mm+(dx*-1.5))+(dx*-0.5))*0.5)+(Lq4*-1))+(cOver*-1)), ((((0mm+(dy*1.5))*1)+(((Lp*0.5)*-1)-feedRise))-(W70*0.5)), h), size=((((((0mm+(dx*-1.5))+(dx*-0.5))*0.5)+(cOver*1))-(((((0mm+(dx*-1.5))+(dx*-0.5))*0.5)+(Lq4*-1))+(cOver*-1))), W70, tCu))
  Branch_1010_Q50_Taper = polyline(z=h, xy: (((((((0mm+(dx*-1.5))+(dx*-0.5))*0.5)+(Lq4*-1))+(cOver*1))-(W70*0)), (((((0mm+(dy*1.5))*1)+(((Lp*0.5)*-1)-feedRise))+(cOver*0))-(W70*-0.5))) ((((((((0mm+(dx*-1.5))+(dx*-0.5))*0.5)+(Lq4*-1))+(Lq50Taper*-1))+(cOver*-1))-(W50*0)), (((((0mm+(dy*1.5))*1)+(((Lp*0.5)*-1)-feedRise))+(cOver*0))-(W50*-0.5))) ((((((((0mm+(dx*-1.5))+(dx*-0.5))*0.5)+(Lq4*-1))+(Lq50Taper*-1))+(cOver*-1))+(W50*0)), (((((0mm+(dy*1.5))*1)+(((Lp*0.5)*-1)-feedRise))+(cOver*0))+(W50*-0.5))) (((((((0mm+(dx*-1.5))+(dx*-0.5))*0.5)+(Lq4*-1))+(cOver*1))+(W70*0)), (((((0mm+(dy*1.5))*1)+(((Lp*0.5)*-1)-feedRise))+(cOver*0))+(W70*-0.5))), closed, covered)
  Branch_1010_Q50_Taper.thicken(tCu)
  Branch_1010_50 = box(corner=((((((0mm+(dx*-1.5))*1)-((LpT-feedRise)*-1))-(L50PatchTaper*-1))+(cOver*-1)), ((((0mm+(dy*1.5))*1)+(((Lp*0.5)*-1)-feedRise))-(W50*0.5)), h), size=((((((((0mm+(dx*-1.5))+(dx*-0.5))*0.5)+(Lq4*-1))+(Lq50Taper*-1))+(cOver*1))-(((((0mm+(dx*-1.5))*1)-((LpT-feedRise)*-1))-(L50PatchTaper*-1))+(cOver*-1))), W50, tCu))
  Branch_1010_50PT_Taper = polyline(z=h, xy: (((((((0mm+(dx*-1.5))*1)-((LpT-feedRise)*-1))-(L50PatchTaper*-1))+(cOver*1))-(W50*0)), (((((0mm+(dy*1.5))*1)+(((Lp*0.5)*-1)-feedRise))+(cOver*0))-(W50*-0.5))) ((((((0mm+(dx*-1.5))*1)-((LpT-feedRise)*-1))+(cOver*-1))-(WpT*0)), (((((0mm+(dy*1.5))*1)+(((Lp*0.5)*-1)-feedRise))+(cOver*0))-(WpT*-0.5))) ((((((0mm+(dx*-1.5))*1)-((LpT-feedRise)*-1))+(cOver*-1))+(WpT*0)), (((((0mm+(dy*1.5))*1)+(((Lp*0.5)*-1)-feedRise))+(cOver*0))+(WpT*-0.5))) (((((((0mm+(dx*-1.5))*1)-((LpT-feedRise)*-1))-(L50PatchTaper*-1))+(cOver*1))+(W50*0)), (((((0mm+(dy*1.5))*1)+(((Lp*0.5)*-1)-feedRise))+(cOver*0))+(W50*-0.5))), closed, covered)
  Branch_1010_50PT_Taper.thicken(tCu)
  Branch_1010_PT = polyline(z=h+tCu/2, xy: (((((0mm+(dx*-1.5))*1)-((LpT-feedRise)*-1))+(cOver*1)), ((((0mm+(dy*1.5))*1)+(((Lp*0.5)*-1)-feedRise))+(cOver*0))) (((0mm+(dx*-1.5))*1), (((0mm+(dy*1.5))*1)+(((Lp*0.5)*-1)-feedRise))) ((((0mm+(dx*-1.5))*1)+(cOver*0)), (((dy*1.5)-(Lp*0.5))+(cOver*1))), section rectangle width=WpT height=tCu bend_type=Curved)
  Patch_r4_c2 = box(corner=(((dx*-0.5)-(Wp*0.5)), ((dy*1.5)-(Lp*0.5)), h), size=(Wp, Lp, tCu))
  Branch_1011_Q = box(corner=(((((0mm+(dx*-1.5))+(dx*-0.5))*0.5)+(cOver*-1)), ((((0mm+(dy*1.5))*1)+(((Lp*0.5)*-1)-feedRise))-(W70*0.5)), h), size=(((((((0mm+(dx*-1.5))+(dx*-0.5))*0.5)+(Lq4*1))+(cOver*1))-((((0mm+(dx*-1.5))+(dx*-0.5))*0.5)+(cOver*-1))), W70, tCu))
  Branch_1011_Q50_Taper = polyline(z=h, xy: (((((((0mm+(dx*-1.5))+(dx*-0.5))*0.5)+(Lq4*1))+(cOver*-1))-(W70*0)), (((((0mm+(dy*1.5))*1)+(((Lp*0.5)*-1)-feedRise))+(cOver*0))-(W70*0.5))) ((((((((0mm+(dx*-1.5))+(dx*-0.5))*0.5)+(Lq4*1))+(Lq50Taper*1))+(cOver*1))-(W50*0)), (((((0mm+(dy*1.5))*1)+(((Lp*0.5)*-1)-feedRise))+(cOver*0))-(W50*0.5))) ((((((((0mm+(dx*-1.5))+(dx*-0.5))*0.5)+(Lq4*1))+(Lq50Taper*1))+(cOver*1))+(W50*0)), (((((0mm+(dy*1.5))*1)+(((Lp*0.5)*-1)-feedRise))+(cOver*0))+(W50*0.5))) (((((((0mm+(dx*-1.5))+(dx*-0.5))*0.5)+(Lq4*1))+(cOver*-1))+(W70*0)), (((((0mm+(dy*1.5))*1)+(((Lp*0.5)*-1)-feedRise))+(cOver*0))+(W70*0.5))), closed, covered)
  Branch_1011_Q50_Taper.thicken(tCu)
  Branch_1011_50 = box(corner=(((((((0mm+(dx*-1.5))+(dx*-0.5))*0.5)+(Lq4*1))+(Lq50Taper*1))+(cOver*-1)), ((((0mm+(dy*1.5))*1)+(((Lp*0.5)*-1)-feedRise))-(W50*0.5)), h), size=(((((((0mm+(dx*-0.5))*1)-((LpT-feedRise)*1))-(L50PatchTaper*1))+(cOver*1))-((((((0mm+(dx*-1.5))+(dx*-0.5))*0.5)+(Lq4*1))+(Lq50Taper*1))+(cOver*-1))), W50, tCu))
  Branch_1011_50PT_Taper = polyline(z=h, xy: (((((((0mm+(dx*-0.5))*1)-((LpT-feedRise)*1))-(L50PatchTaper*1))+(cOver*-1))-(W50*0)), (((((0mm+(dy*1.5))*1)+(((Lp*0.5)*-1)-feedRise))+(cOver*0))-(W50*0.5))) ((((((0mm+(dx*-0.5))*1)-((LpT-feedRise)*1))+(cOver*1))-(WpT*0)), (((((0mm+(dy*1.5))*1)+(((Lp*0.5)*-1)-feedRise))+(cOver*0))-(WpT*0.5))) ((((((0mm+(dx*-0.5))*1)-((LpT-feedRise)*1))+(cOver*1))+(WpT*0)), (((((0mm+(dy*1.5))*1)+(((Lp*0.5)*-1)-feedRise))+(cOver*0))+(WpT*0.5))) (((((((0mm+(dx*-0.5))*1)-((LpT-feedRise)*1))-(L50PatchTaper*1))+(cOver*-1))+(W50*0)), (((((0mm+(dy*1.5))*1)+(((Lp*0.5)*-1)-feedRise))+(cOver*0))+(W50*0.5))), closed, covered)
  Branch_1011_50PT_Taper.thicken(tCu)
  Branch_1011_PT = polyline(z=h+tCu/2, xy: (((((0mm+(dx*-0.5))*1)-((LpT-feedRise)*1))+(cOver*-1)), ((((0mm+(dy*1.5))*1)+(((Lp*0.5)*-1)-feedRise))+(cOver*0))) (((0mm+(dx*-0.5))*1), (((0mm+(dy*1.5))*1)+(((Lp*0.5)*-1)-feedRise))) ((((0mm+(dx*-0.5))*1)+(cOver*0)), (((dy*1.5)-(Lp*0.5))+(cOver*1))), section rectangle width=WpT height=tCu bend_type=Curved)
  Branch_11_Q = box(corner=(((((((0mm+(dx*-1.5))+(dx*-0.5))+(dx*0.5))+(dx*1.5))*0.25)+(cOver*-1)), (((((0mm+(dy*0.5))+(dy*1.5))*0.5)+(((Lp*0.5)*-1)-feedRise))-(W70*0.5)), h), size=(((((((((0mm+(dx*-1.5))+(dx*-0.5))+(dx*0.5))+(dx*1.5))*0.25)+(Lq2*1))+(cOver*1))-((((((0mm+(dx*-1.5))+(dx*-0.5))+(dx*0.5))+(dx*1.5))*0.25)+(cOver*-1))), W70, tCu))
  Branch_11_Q50_Taper = polyline(z=h, xy: (((((((((0mm+(dx*-1.5))+(dx*-0.5))+(dx*0.5))+(dx*1.5))*0.25)+(Lq2*1))+(cOver*-0.7071067812))-(W70*-0.3535533906)), ((((((0mm+(dy*0.5))+(dy*1.5))*0.5)+(((Lp*0.5)*-1)-feedRise))+(cOver*-0.7071067812))-(W70*0.3535533906))) ((((((((((0mm+(dx*-1.5))+(dx*-0.5))+(dx*0.5))+(dx*1.5))*0.25)+(Lq2*1))+(Lq50Taper*0.7071067812))+(cOver*0.7071067812))-(W50*-0.3535533906)), (((((((0mm+(dy*0.5))+(dy*1.5))*0.5)+(((Lp*0.5)*-1)-feedRise))+(Lq50Taper*0.7071067812))+(cOver*0.7071067812))-(W50*0.3535533906))) ((((((((((0mm+(dx*-1.5))+(dx*-0.5))+(dx*0.5))+(dx*1.5))*0.25)+(Lq2*1))+(Lq50Taper*0.7071067812))+(cOver*0.7071067812))+(W50*-0.3535533906)), (((((((0mm+(dy*0.5))+(dy*1.5))*0.5)+(((Lp*0.5)*-1)-feedRise))+(Lq50Taper*0.7071067812))+(cOver*0.7071067812))+(W50*0.3535533906))) (((((((((0mm+(dx*-1.5))+(dx*-0.5))+(dx*0.5))+(dx*1.5))*0.25)+(Lq2*1))+(cOver*-0.7071067812))+(W70*-0.3535533906)), ((((((0mm+(dy*0.5))+(dy*1.5))*0.5)+(((Lp*0.5)*-1)-feedRise))+(cOver*-0.7071067812))+(W70*0.3535533906))), closed, covered)
  Branch_11_Q50_Taper.thicken(tCu)
  Branch_11_BendFill = cylinder(axis=Z, base_centre=(((((((0mm+(dx*-1.5))+(dx*-0.5))+(dx*0.5))+(dx*1.5))*0.25)+(Lq2*1)), ((((0mm+(dy*0.5))+(dy*1.5))*0.5)+(((Lp*0.5)*-1)-feedRise)), h), radius=(W70*0.62), height=tCu)
  Branch_11_50_Clearance = polyline(z=h+tCu/2, xy: (((((((((0mm+(dx*-1.5))+(dx*-0.5))+(dx*0.5))+(dx*1.5))*0.25)+(Lq2*1))+(Lq50Taper*0.7071067812))+(cOver*-0.7071067812)), ((((((0mm+(dy*0.5))+(dy*1.5))*0.5)+(((Lp*0.5)*-1)-feedRise))+(Lq50Taper*0.7071067812))+(cOver*-0.7071067812))) ((((((((0mm+(dx*-1.5))+(dx*-0.5))+(dx*0.5))+(dx*1.5))*0.25)+(Lq2*1))+(((Lp*0.5)+feedRise)*1)), (((((0mm+(dy*0.5))+(dy*1.5))*0.5)+(((Lp*0.5)*-1)-feedRise))+((Lp*0.5)+feedRise))) ((((((0mm+(dx*0.5))+(dx*1.5))*0.5)-(teeApproach*1))-(((Lp*0.5)+feedRise)*1)), (((((0mm+(dy*0.5))+(dy*1.5))*0.5)+(((Lp*0.5)*-1)-feedRise))+((Lp*0.5)+feedRise))) (((((0mm+(dx*0.5))+(dx*1.5))*0.5)-(teeApproach*1)), ((((0mm+(dy*0.5))+(dy*1.5))*0.5)+(((Lp*0.5)*-1)-feedRise))) (((((0mm+(dx*0.5))+(dx*1.5))*0.5)+(cOver*1)), (((((0mm+(dy*0.5))+(dy*1.5))*0.5)+(((Lp*0.5)*-1)-feedRise))+(cOver*0))), section rectangle width=W50 height=tCu bend_type=Curved)
  RoundTee_11 = cylinder(axis=Z, base_centre=((((0mm+(dx*0.5))+(dx*1.5))*0.5), ((((0mm+(dy*0.5))+(dy*1.5))*0.5)+(((Lp*0.5)*-1)-feedRise)), h), radius=junctionR, height=tCu)
  Branch_110_Q = box(corner=(((((0mm+(dx*0.5))+(dx*1.5))*0.5)-(W70*0.5)), ((((((0mm+(dy*0.5))+(dy*1.5))*0.5)+(((Lp*0.5)*-1)-feedRise))+(Lq3*-1))+(cOver*-1)), h), size=(W70, ((((((0mm+(dy*0.5))+(dy*1.5))*0.5)+(((Lp*0.5)*-1)-feedRise))+(cOver*1))-((((((0mm+(dy*0.5))+(dy*1.5))*0.5)+(((Lp*0.5)*-1)-feedRise))+(Lq3*-1))+(cOver*-1))), tCu))
  Branch_110_Q50_Taper = polyline(z=h, xy: ((((((0mm+(dx*0.5))+(dx*1.5))*0.5)+(cOver*0))-(W70*0.5)), (((((((0mm+(dy*0.5))+(dy*1.5))*0.5)+(((Lp*0.5)*-1)-feedRise))+(Lq3*-1))+(cOver*1))-(W70*0))) ((((((0mm+(dx*0.5))+(dx*1.5))*0.5)+(cOver*0))-(W50*0.5)), ((((((((0mm+(dy*0.5))+(dy*1.5))*0.5)+(((Lp*0.5)*-1)-feedRise))+(Lq3*-1))+(Lq50Taper*-1))+(cOver*-1))-(W50*0))) ((((((0mm+(dx*0.5))+(dx*1.5))*0.5)+(cOver*0))+(W50*0.5)), ((((((((0mm+(dy*0.5))+(dy*1.5))*0.5)+(((Lp*0.5)*-1)-feedRise))+(Lq3*-1))+(Lq50Taper*-1))+(cOver*-1))+(W50*0))) ((((((0mm+(dx*0.5))+(dx*1.5))*0.5)+(cOver*0))+(W70*0.5)), (((((((0mm+(dy*0.5))+(dy*1.5))*0.5)+(((Lp*0.5)*-1)-feedRise))+(Lq3*-1))+(cOver*1))+(W70*0))), closed, covered)
  Branch_110_Q50_Taper.thicken(tCu)
  Branch_110_50 = box(corner=(((((0mm+(dx*0.5))+(dx*1.5))*0.5)-(W50*0.5)), ((((0mm+(dy*0.5))*1)+(((Lp*0.5)*-1)-feedRise))+(cOver*-1)), h), size=(W50, ((((((((0mm+(dy*0.5))+(dy*1.5))*0.5)+(((Lp*0.5)*-1)-feedRise))+(Lq3*-1))+(Lq50Taper*-1))+(cOver*1))-((((0mm+(dy*0.5))*1)+(((Lp*0.5)*-1)-feedRise))+(cOver*-1))), tCu))
  RoundTee_110 = cylinder(axis=Z, base_centre=((((0mm+(dx*0.5))+(dx*1.5))*0.5), (((0mm+(dy*0.5))*1)+(((Lp*0.5)*-1)-feedRise)), h), radius=junctionR, height=tCu)
  Patch_r3_c3 = box(corner=(((dx*0.5)-(Wp*0.5)), ((dy*0.5)-(Lp*0.5)), h), size=(Wp, Lp, tCu))
  Branch_1100_Q = box(corner=((((((0mm+(dx*0.5))+(dx*1.5))*0.5)+(Lq4*-1))+(cOver*-1)), ((((0mm+(dy*0.5))*1)+(((Lp*0.5)*-1)-feedRise))-(W70*0.5)), h), size=((((((0mm+(dx*0.5))+(dx*1.5))*0.5)+(cOver*1))-(((((0mm+(dx*0.5))+(dx*1.5))*0.5)+(Lq4*-1))+(cOver*-1))), W70, tCu))
  Branch_1100_Q50_Taper = polyline(z=h, xy: (((((((0mm+(dx*0.5))+(dx*1.5))*0.5)+(Lq4*-1))+(cOver*1))-(W70*0)), (((((0mm+(dy*0.5))*1)+(((Lp*0.5)*-1)-feedRise))+(cOver*0))-(W70*-0.5))) ((((((((0mm+(dx*0.5))+(dx*1.5))*0.5)+(Lq4*-1))+(Lq50Taper*-1))+(cOver*-1))-(W50*0)), (((((0mm+(dy*0.5))*1)+(((Lp*0.5)*-1)-feedRise))+(cOver*0))-(W50*-0.5))) ((((((((0mm+(dx*0.5))+(dx*1.5))*0.5)+(Lq4*-1))+(Lq50Taper*-1))+(cOver*-1))+(W50*0)), (((((0mm+(dy*0.5))*1)+(((Lp*0.5)*-1)-feedRise))+(cOver*0))+(W50*-0.5))) (((((((0mm+(dx*0.5))+(dx*1.5))*0.5)+(Lq4*-1))+(cOver*1))+(W70*0)), (((((0mm+(dy*0.5))*1)+(((Lp*0.5)*-1)-feedRise))+(cOver*0))+(W70*-0.5))), closed, covered)
  Branch_1100_Q50_Taper.thicken(tCu)
  Branch_1100_50 = box(corner=((((((0mm+(dx*0.5))*1)-((LpT-feedRise)*-1))-(L50PatchTaper*-1))+(cOver*-1)), ((((0mm+(dy*0.5))*1)+(((Lp*0.5)*-1)-feedRise))-(W50*0.5)), h), size=((((((((0mm+(dx*0.5))+(dx*1.5))*0.5)+(Lq4*-1))+(Lq50Taper*-1))+(cOver*1))-(((((0mm+(dx*0.5))*1)-((LpT-feedRise)*-1))-(L50PatchTaper*-1))+(cOver*-1))), W50, tCu))
  Branch_1100_50PT_Taper = polyline(z=h, xy: (((((((0mm+(dx*0.5))*1)-((LpT-feedRise)*-1))-(L50PatchTaper*-1))+(cOver*1))-(W50*0)), (((((0mm+(dy*0.5))*1)+(((Lp*0.5)*-1)-feedRise))+(cOver*0))-(W50*-0.5))) ((((((0mm+(dx*0.5))*1)-((LpT-feedRise)*-1))+(cOver*-1))-(WpT*0)), (((((0mm+(dy*0.5))*1)+(((Lp*0.5)*-1)-feedRise))+(cOver*0))-(WpT*-0.5))) ((((((0mm+(dx*0.5))*1)-((LpT-feedRise)*-1))+(cOver*-1))+(WpT*0)), (((((0mm+(dy*0.5))*1)+(((Lp*0.5)*-1)-feedRise))+(cOver*0))+(WpT*-0.5))) (((((((0mm+(dx*0.5))*1)-((LpT-feedRise)*-1))-(L50PatchTaper*-1))+(cOver*1))+(W50*0)), (((((0mm+(dy*0.5))*1)+(((Lp*0.5)*-1)-feedRise))+(cOver*0))+(W50*-0.5))), closed, covered)
  Branch_1100_50PT_Taper.thicken(tCu)
  Branch_1100_PT = polyline(z=h+tCu/2, xy: (((((0mm+(dx*0.5))*1)-((LpT-feedRise)*-1))+(cOver*1)), ((((0mm+(dy*0.5))*1)+(((Lp*0.5)*-1)-feedRise))+(cOver*0))) (((0mm+(dx*0.5))*1), (((0mm+(dy*0.5))*1)+(((Lp*0.5)*-1)-feedRise))) ((((0mm+(dx*0.5))*1)+(cOver*0)), (((dy*0.5)-(Lp*0.5))+(cOver*1))), section rectangle width=WpT height=tCu bend_type=Curved)
  Patch_r3_c4 = box(corner=(((dx*1.5)-(Wp*0.5)), ((dy*0.5)-(Lp*0.5)), h), size=(Wp, Lp, tCu))
  Branch_1101_Q = box(corner=(((((0mm+(dx*0.5))+(dx*1.5))*0.5)+(cOver*-1)), ((((0mm+(dy*0.5))*1)+(((Lp*0.5)*-1)-feedRise))-(W70*0.5)), h), size=(((((((0mm+(dx*0.5))+(dx*1.5))*0.5)+(Lq4*1))+(cOver*1))-((((0mm+(dx*0.5))+(dx*1.5))*0.5)+(cOver*-1))), W70, tCu))
  Branch_1101_Q50_Taper = polyline(z=h, xy: (((((((0mm+(dx*0.5))+(dx*1.5))*0.5)+(Lq4*1))+(cOver*-1))-(W70*0)), (((((0mm+(dy*0.5))*1)+(((Lp*0.5)*-1)-feedRise))+(cOver*0))-(W70*0.5))) ((((((((0mm+(dx*0.5))+(dx*1.5))*0.5)+(Lq4*1))+(Lq50Taper*1))+(cOver*1))-(W50*0)), (((((0mm+(dy*0.5))*1)+(((Lp*0.5)*-1)-feedRise))+(cOver*0))-(W50*0.5))) ((((((((0mm+(dx*0.5))+(dx*1.5))*0.5)+(Lq4*1))+(Lq50Taper*1))+(cOver*1))+(W50*0)), (((((0mm+(dy*0.5))*1)+(((Lp*0.5)*-1)-feedRise))+(cOver*0))+(W50*0.5))) (((((((0mm+(dx*0.5))+(dx*1.5))*0.5)+(Lq4*1))+(cOver*-1))+(W70*0)), (((((0mm+(dy*0.5))*1)+(((Lp*0.5)*-1)-feedRise))+(cOver*0))+(W70*0.5))), closed, covered)
  Branch_1101_Q50_Taper.thicken(tCu)
  Branch_1101_50 = box(corner=(((((((0mm+(dx*0.5))+(dx*1.5))*0.5)+(Lq4*1))+(Lq50Taper*1))+(cOver*-1)), ((((0mm+(dy*0.5))*1)+(((Lp*0.5)*-1)-feedRise))-(W50*0.5)), h), size=(((((((0mm+(dx*1.5))*1)-((LpT-feedRise)*1))-(L50PatchTaper*1))+(cOver*1))-((((((0mm+(dx*0.5))+(dx*1.5))*0.5)+(Lq4*1))+(Lq50Taper*1))+(cOver*-1))), W50, tCu))
  Branch_1101_50PT_Taper = polyline(z=h, xy: (((((((0mm+(dx*1.5))*1)-((LpT-feedRise)*1))-(L50PatchTaper*1))+(cOver*-1))-(W50*0)), (((((0mm+(dy*0.5))*1)+(((Lp*0.5)*-1)-feedRise))+(cOver*0))-(W50*0.5))) ((((((0mm+(dx*1.5))*1)-((LpT-feedRise)*1))+(cOver*1))-(WpT*0)), (((((0mm+(dy*0.5))*1)+(((Lp*0.5)*-1)-feedRise))+(cOver*0))-(WpT*0.5))) ((((((0mm+(dx*1.5))*1)-((LpT-feedRise)*1))+(cOver*1))+(WpT*0)), (((((0mm+(dy*0.5))*1)+(((Lp*0.5)*-1)-feedRise))+(cOver*0))+(WpT*0.5))) (((((((0mm+(dx*1.5))*1)-((LpT-feedRise)*1))-(L50PatchTaper*1))+(cOver*-1))+(W50*0)), (((((0mm+(dy*0.5))*1)+(((Lp*0.5)*-1)-feedRise))+(cOver*0))+(W50*0.5))), closed, covered)
  Branch_1101_50PT_Taper.thicken(tCu)
  Branch_1101_PT = polyline(z=h+tCu/2, xy: (((((0mm+(dx*1.5))*1)-((LpT-feedRise)*1))+(cOver*-1)), ((((0mm+(dy*0.5))*1)+(((Lp*0.5)*-1)-feedRise))+(cOver*0))) (((0mm+(dx*1.5))*1), (((0mm+(dy*0.5))*1)+(((Lp*0.5)*-1)-feedRise))) ((((0mm+(dx*1.5))*1)+(cOver*0)), (((dy*0.5)-(Lp*0.5))+(cOver*1))), section rectangle width=WpT height=tCu bend_type=Curved)
  Branch_111_Q = box(corner=(((((0mm+(dx*0.5))+(dx*1.5))*0.5)-(W70*0.5)), (((((0mm+(dy*0.5))+(dy*1.5))*0.5)+(((Lp*0.5)*-1)-feedRise))+(cOver*-1)), h), size=(W70, (((((((0mm+(dy*0.5))+(dy*1.5))*0.5)+(((Lp*0.5)*-1)-feedRise))+(Lq3*1))+(cOver*1))-(((((0mm+(dy*0.5))+(dy*1.5))*0.5)+(((Lp*0.5)*-1)-feedRise))+(cOver*-1))), tCu))
  Branch_111_Q50_Taper = polyline(z=h, xy: ((((((0mm+(dx*0.5))+(dx*1.5))*0.5)+(cOver*0))-(W70*-0.5)), (((((((0mm+(dy*0.5))+(dy*1.5))*0.5)+(((Lp*0.5)*-1)-feedRise))+(Lq3*1))+(cOver*-1))-(W70*0))) ((((((0mm+(dx*0.5))+(dx*1.5))*0.5)+(cOver*0))-(W50*-0.5)), ((((((((0mm+(dy*0.5))+(dy*1.5))*0.5)+(((Lp*0.5)*-1)-feedRise))+(Lq3*1))+(Lq50Taper*1))+(cOver*1))-(W50*0))) ((((((0mm+(dx*0.5))+(dx*1.5))*0.5)+(cOver*0))+(W50*-0.5)), ((((((((0mm+(dy*0.5))+(dy*1.5))*0.5)+(((Lp*0.5)*-1)-feedRise))+(Lq3*1))+(Lq50Taper*1))+(cOver*1))+(W50*0))) ((((((0mm+(dx*0.5))+(dx*1.5))*0.5)+(cOver*0))+(W70*-0.5)), (((((((0mm+(dy*0.5))+(dy*1.5))*0.5)+(((Lp*0.5)*-1)-feedRise))+(Lq3*1))+(cOver*-1))+(W70*0))), closed, covered)
  Branch_111_Q50_Taper.thicken(tCu)
  Branch_111_50 = box(corner=(((((0mm+(dx*0.5))+(dx*1.5))*0.5)-(W50*0.5)), (((((((0mm+(dy*0.5))+(dy*1.5))*0.5)+(((Lp*0.5)*-1)-feedRise))+(Lq3*1))+(Lq50Taper*1))+(cOver*-1)), h), size=(W50, (((((0mm+(dy*1.5))*1)+(((Lp*0.5)*-1)-feedRise))+(cOver*1))-(((((((0mm+(dy*0.5))+(dy*1.5))*0.5)+(((Lp*0.5)*-1)-feedRise))+(Lq3*1))+(Lq50Taper*1))+(cOver*-1))), tCu))
  RoundTee_111 = cylinder(axis=Z, base_centre=((((0mm+(dx*0.5))+(dx*1.5))*0.5), (((0mm+(dy*1.5))*1)+(((Lp*0.5)*-1)-feedRise)), h), radius=junctionR, height=tCu)
  Patch_r4_c3 = box(corner=(((dx*0.5)-(Wp*0.5)), ((dy*1.5)-(Lp*0.5)), h), size=(Wp, Lp, tCu))
  Branch_1110_Q = box(corner=((((((0mm+(dx*0.5))+(dx*1.5))*0.5)+(Lq4*-1))+(cOver*-1)), ((((0mm+(dy*1.5))*1)+(((Lp*0.5)*-1)-feedRise))-(W70*0.5)), h), size=((((((0mm+(dx*0.5))+(dx*1.5))*0.5)+(cOver*1))-(((((0mm+(dx*0.5))+(dx*1.5))*0.5)+(Lq4*-1))+(cOver*-1))), W70, tCu))
  Branch_1110_Q50_Taper = polyline(z=h, xy: (((((((0mm+(dx*0.5))+(dx*1.5))*0.5)+(Lq4*-1))+(cOver*1))-(W70*0)), (((((0mm+(dy*1.5))*1)+(((Lp*0.5)*-1)-feedRise))+(cOver*0))-(W70*-0.5))) ((((((((0mm+(dx*0.5))+(dx*1.5))*0.5)+(Lq4*-1))+(Lq50Taper*-1))+(cOver*-1))-(W50*0)), (((((0mm+(dy*1.5))*1)+(((Lp*0.5)*-1)-feedRise))+(cOver*0))-(W50*-0.5))) ((((((((0mm+(dx*0.5))+(dx*1.5))*0.5)+(Lq4*-1))+(Lq50Taper*-1))+(cOver*-1))+(W50*0)), (((((0mm+(dy*1.5))*1)+(((Lp*0.5)*-1)-feedRise))+(cOver*0))+(W50*-0.5))) (((((((0mm+(dx*0.5))+(dx*1.5))*0.5)+(Lq4*-1))+(cOver*1))+(W70*0)), (((((0mm+(dy*1.5))*1)+(((Lp*0.5)*-1)-feedRise))+(cOver*0))+(W70*-0.5))), closed, covered)
  Branch_1110_Q50_Taper.thicken(tCu)
  Branch_1110_50 = box(corner=((((((0mm+(dx*0.5))*1)-((LpT-feedRise)*-1))-(L50PatchTaper*-1))+(cOver*-1)), ((((0mm+(dy*1.5))*1)+(((Lp*0.5)*-1)-feedRise))-(W50*0.5)), h), size=((((((((0mm+(dx*0.5))+(dx*1.5))*0.5)+(Lq4*-1))+(Lq50Taper*-1))+(cOver*1))-(((((0mm+(dx*0.5))*1)-((LpT-feedRise)*-1))-(L50PatchTaper*-1))+(cOver*-1))), W50, tCu))
  Branch_1110_50PT_Taper = polyline(z=h, xy: (((((((0mm+(dx*0.5))*1)-((LpT-feedRise)*-1))-(L50PatchTaper*-1))+(cOver*1))-(W50*0)), (((((0mm+(dy*1.5))*1)+(((Lp*0.5)*-1)-feedRise))+(cOver*0))-(W50*-0.5))) ((((((0mm+(dx*0.5))*1)-((LpT-feedRise)*-1))+(cOver*-1))-(WpT*0)), (((((0mm+(dy*1.5))*1)+(((Lp*0.5)*-1)-feedRise))+(cOver*0))-(WpT*-0.5))) ((((((0mm+(dx*0.5))*1)-((LpT-feedRise)*-1))+(cOver*-1))+(WpT*0)), (((((0mm+(dy*1.5))*1)+(((Lp*0.5)*-1)-feedRise))+(cOver*0))+(WpT*-0.5))) (((((((0mm+(dx*0.5))*1)-((LpT-feedRise)*-1))-(L50PatchTaper*-1))+(cOver*1))+(W50*0)), (((((0mm+(dy*1.5))*1)+(((Lp*0.5)*-1)-feedRise))+(cOver*0))+(W50*-0.5))), closed, covered)
  Branch_1110_50PT_Taper.thicken(tCu)
  Branch_1110_PT = polyline(z=h+tCu/2, xy: (((((0mm+(dx*0.5))*1)-((LpT-feedRise)*-1))+(cOver*1)), ((((0mm+(dy*1.5))*1)+(((Lp*0.5)*-1)-feedRise))+(cOver*0))) (((0mm+(dx*0.5))*1), (((0mm+(dy*1.5))*1)+(((Lp*0.5)*-1)-feedRise))) ((((0mm+(dx*0.5))*1)+(cOver*0)), (((dy*1.5)-(Lp*0.5))+(cOver*1))), section rectangle width=WpT height=tCu bend_type=Curved)
  Patch_r4_c4 = box(corner=(((dx*1.5)-(Wp*0.5)), ((dy*1.5)-(Lp*0.5)), h), size=(Wp, Lp, tCu))
  Branch_1111_Q = box(corner=(((((0mm+(dx*0.5))+(dx*1.5))*0.5)+(cOver*-1)), ((((0mm+(dy*1.5))*1)+(((Lp*0.5)*-1)-feedRise))-(W70*0.5)), h), size=(((((((0mm+(dx*0.5))+(dx*1.5))*0.5)+(Lq4*1))+(cOver*1))-((((0mm+(dx*0.5))+(dx*1.5))*0.5)+(cOver*-1))), W70, tCu))
  Branch_1111_Q50_Taper = polyline(z=h, xy: (((((((0mm+(dx*0.5))+(dx*1.5))*0.5)+(Lq4*1))+(cOver*-1))-(W70*0)), (((((0mm+(dy*1.5))*1)+(((Lp*0.5)*-1)-feedRise))+(cOver*0))-(W70*0.5))) ((((((((0mm+(dx*0.5))+(dx*1.5))*0.5)+(Lq4*1))+(Lq50Taper*1))+(cOver*1))-(W50*0)), (((((0mm+(dy*1.5))*1)+(((Lp*0.5)*-1)-feedRise))+(cOver*0))-(W50*0.5))) ((((((((0mm+(dx*0.5))+(dx*1.5))*0.5)+(Lq4*1))+(Lq50Taper*1))+(cOver*1))+(W50*0)), (((((0mm+(dy*1.5))*1)+(((Lp*0.5)*-1)-feedRise))+(cOver*0))+(W50*0.5))) (((((((0mm+(dx*0.5))+(dx*1.5))*0.5)+(Lq4*1))+(cOver*-1))+(W70*0)), (((((0mm+(dy*1.5))*1)+(((Lp*0.5)*-1)-feedRise))+(cOver*0))+(W70*0.5))), closed, covered)
  Branch_1111_Q50_Taper.thicken(tCu)
  Branch_1111_50 = box(corner=(((((((0mm+(dx*0.5))+(dx*1.5))*0.5)+(Lq4*1))+(Lq50Taper*1))+(cOver*-1)), ((((0mm+(dy*1.5))*1)+(((Lp*0.5)*-1)-feedRise))-(W50*0.5)), h), size=(((((((0mm+(dx*1.5))*1)-((LpT-feedRise)*1))-(L50PatchTaper*1))+(cOver*1))-((((((0mm+(dx*0.5))+(dx*1.5))*0.5)+(Lq4*1))+(Lq50Taper*1))+(cOver*-1))), W50, tCu))
  Branch_1111_50PT_Taper = polyline(z=h, xy: (((((((0mm+(dx*1.5))*1)-((LpT-feedRise)*1))-(L50PatchTaper*1))+(cOver*-1))-(W50*0)), (((((0mm+(dy*1.5))*1)+(((Lp*0.5)*-1)-feedRise))+(cOver*0))-(W50*0.5))) ((((((0mm+(dx*1.5))*1)-((LpT-feedRise)*1))+(cOver*1))-(WpT*0)), (((((0mm+(dy*1.5))*1)+(((Lp*0.5)*-1)-feedRise))+(cOver*0))-(WpT*0.5))) ((((((0mm+(dx*1.5))*1)-((LpT-feedRise)*1))+(cOver*1))+(WpT*0)), (((((0mm+(dy*1.5))*1)+(((Lp*0.5)*-1)-feedRise))+(cOver*0))+(WpT*0.5))) (((((((0mm+(dx*1.5))*1)-((LpT-feedRise)*1))-(L50PatchTaper*1))+(cOver*-1))+(W50*0)), (((((0mm+(dy*1.5))*1)+(((Lp*0.5)*-1)-feedRise))+(cOver*0))+(W50*0.5))), closed, covered)
  Branch_1111_50PT_Taper.thicken(tCu)
  Branch_1111_PT = polyline(z=h+tCu/2, xy: (((((0mm+(dx*1.5))*1)-((LpT-feedRise)*1))+(cOver*-1)), ((((0mm+(dy*1.5))*1)+(((Lp*0.5)*-1)-feedRise))+(cOver*0))) (((0mm+(dx*1.5))*1), (((0mm+(dy*1.5))*1)+(((Lp*0.5)*-1)-feedRise))) ((((0mm+(dx*1.5))*1)+(cOver*0)), (((dy*1.5)-(Lp*0.5))+(cOver*1))), section rectangle width=WpT height=tCu bend_type=Curved)
  TopCopper.unite(Input50_Rerouted, InputMatchStub, RoundTee_InputMatch, Branch_0_Q, Branch_0_Q50_Taper, Branch_0_50, RoundTee_0, Branch_00_Q, Branch_00_Q50_Taper, Branch_00_BendFill, Branch_00_50_Clearance, RoundTee_00, Branch_000_Q, Branch_000_Q50_Taper, Branch_000_50, RoundTee_000, Patch_r1_c1, Branch_0000_Q, Branch_0000_Q50_Taper, Branch_0000_50, Branch_0000_50PT_Taper, Branch_0000_PT, Patch_r1_c2, Branch_0001_Q, Branch_0001_Q50_Taper, Branch_0001_50, Branch_0001_50PT_Taper, Branch_0001_PT, Branch_001_Q, Branch_001_Q50_Taper, Branch_001_50, RoundTee_001, Patch_r2_c1, Branch_0010_Q, Branch_0010_Q50_Taper, Branch_0010_50, Branch_0010_50PT_Taper, Branch_0010_PT, Patch_r2_c2, Branch_0011_Q, Branch_0011_Q50_Taper, Branch_0011_50, Branch_0011_50PT_Taper, Branch_0011_PT, Branch_01_Q, Branch_01_Q50_Taper, Branch_01_BendFill, Branch_01_50_Clearance, RoundTee_01, Branch_010_Q, Branch_010_Q50_Taper, Branch_010_50, RoundTee_010, Patch_r1_c3, Branch_0100_Q, Branch_0100_Q50_Taper, Branch_0100_50, Branch_0100_50PT_Taper, Branch_0100_PT, Patch_r1_c4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)
  Air [vacuum] = box(corner=(-boardX/2-airPad, -boardY/2-airPad, -tCu-airPad), size=(boardX+2*airPad, boardY+2*airPad, h+2*tCu+2*airPad))
  PortSheet = rectangle(corner=((boardX*0.5), (inputY-(W50*0.5)), 0mm), y_size=W50, z_size=h)
boundaries and excitations:
  Radiation: Radiation Objects=Air
  P1: Lumped Port Faces=PortSheet.face LumpedPortType=Modal Modes{Mode1{IntLine{(80.5, 0, 0) -> (80.5, 0, 1.6)} CharImp=Zpi RenormImp=50ohm}} Impedance=50ohm
setups:
  Setup1: HfssDriven Frequency=5.85GHz MaxDeltaS=0.02 MaximumPasses=18 MinimumPasses=3 MinimumConvergedPasses=2 PercentRefinement=8 BasisOrder=1 PortAccuracy=2 DrivenSolverType="Direct Solver"
    sweep WideSweep: 5.3GHz to 6.4GHz step 0.005GHz; Type=Interpolating InterpTolerance=0.5 InterpMaxSolns=250 InterpUsePortImped=false PassivityErrorTolerance=0.0001
    sweep BandFields: 5.7GHz to 6GHz step 0.15GHz; Type=Discrete SaveFields SaveRadFields
source amplitudes:
  P1:1: 1W 0deg
optimetrics:
  ParametricSetup1: Parametric Sim._Setups=[Setup1]
    sweep Lp: LIN 10.398mm 10.413mm 0.005mm
radiation setups:
  Sphere: Infinite Sphere Theta=0deg..180deg step 2deg Phi=-180deg..180deg step 2deg
reports:
  S Parameter Plot1: dB(S(P1,P1)) vs Freq on Setup1 : WideSweep [Lp=all stubD=7.4mm]; markers MX1 at x=5.2e+09, MY1 at y=-10.023
